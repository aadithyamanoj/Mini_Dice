.meas tran vdout0_0ck40 FIND v(dout0_0) AT=25.025n

.meas tran vdout0_1ck40 FIND v(dout0_1) AT=25.025n

.meas tran vdout0_2ck40 FIND v(dout0_2) AT=25.025n

.meas tran vdout0_3ck40 FIND v(dout0_3) AT=25.025n

.meas tran vdout0_4ck40 FIND v(dout0_4) AT=25.025n

.meas tran vdout0_5ck40 FIND v(dout0_5) AT=25.025n

.meas tran vdout0_6ck40 FIND v(dout0_6) AT=25.025n

.meas tran vdout0_7ck40 FIND v(dout0_7) AT=25.025n

.meas tran vdout0_8ck40 FIND v(dout0_8) AT=25.025n

.meas tran vdout0_9ck40 FIND v(dout0_9) AT=25.025n

.meas tran vdout0_10ck40 FIND v(dout0_10) AT=25.025n

.meas tran vdout0_11ck40 FIND v(dout0_11) AT=25.025n

.meas tran vdout0_12ck40 FIND v(dout0_12) AT=25.025n

.meas tran vdout0_13ck40 FIND v(dout0_13) AT=25.025n

.meas tran vdout0_14ck40 FIND v(dout0_14) AT=25.025n

.meas tran vdout0_15ck40 FIND v(dout0_15) AT=25.025n

.meas tran vdout0_16ck40 FIND v(dout0_16) AT=25.025n

.meas tran vdout0_17ck40 FIND v(dout0_17) AT=25.025n

.meas tran vdout0_18ck40 FIND v(dout0_18) AT=25.025n

.meas tran vdout0_19ck40 FIND v(dout0_19) AT=25.025n

.meas tran vdout0_20ck40 FIND v(dout0_20) AT=25.025n

.meas tran vdout0_21ck40 FIND v(dout0_21) AT=25.025n

.meas tran vdout0_22ck40 FIND v(dout0_22) AT=25.025n

.meas tran vdout0_23ck40 FIND v(dout0_23) AT=25.025n

.meas tran vdout0_24ck40 FIND v(dout0_24) AT=25.025n

.meas tran vdout0_25ck40 FIND v(dout0_25) AT=25.025n

.meas tran vdout0_26ck40 FIND v(dout0_26) AT=25.025n

.meas tran vdout0_27ck40 FIND v(dout0_27) AT=25.025n

.meas tran vdout0_28ck40 FIND v(dout0_28) AT=25.025n

.meas tran vdout0_29ck40 FIND v(dout0_29) AT=25.025n

.meas tran vdout0_30ck40 FIND v(dout0_30) AT=25.025n

.meas tran vdout0_31ck40 FIND v(dout0_31) AT=25.025n

.meas tran vdout0_0ck60 FIND v(dout0_0) AT=35.025n

.meas tran vdout0_1ck60 FIND v(dout0_1) AT=35.025n

.meas tran vdout0_2ck60 FIND v(dout0_2) AT=35.025n

.meas tran vdout0_3ck60 FIND v(dout0_3) AT=35.025n

.meas tran vdout0_4ck60 FIND v(dout0_4) AT=35.025n

.meas tran vdout0_5ck60 FIND v(dout0_5) AT=35.025n

.meas tran vdout0_6ck60 FIND v(dout0_6) AT=35.025n

.meas tran vdout0_7ck60 FIND v(dout0_7) AT=35.025n

.meas tran vdout0_8ck60 FIND v(dout0_8) AT=35.025n

.meas tran vdout0_9ck60 FIND v(dout0_9) AT=35.025n

.meas tran vdout0_10ck60 FIND v(dout0_10) AT=35.025n

.meas tran vdout0_11ck60 FIND v(dout0_11) AT=35.025n

.meas tran vdout0_12ck60 FIND v(dout0_12) AT=35.025n

.meas tran vdout0_13ck60 FIND v(dout0_13) AT=35.025n

.meas tran vdout0_14ck60 FIND v(dout0_14) AT=35.025n

.meas tran vdout0_15ck60 FIND v(dout0_15) AT=35.025n

.meas tran vdout0_16ck60 FIND v(dout0_16) AT=35.025n

.meas tran vdout0_17ck60 FIND v(dout0_17) AT=35.025n

.meas tran vdout0_18ck60 FIND v(dout0_18) AT=35.025n

.meas tran vdout0_19ck60 FIND v(dout0_19) AT=35.025n

.meas tran vdout0_20ck60 FIND v(dout0_20) AT=35.025n

.meas tran vdout0_21ck60 FIND v(dout0_21) AT=35.025n

.meas tran vdout0_22ck60 FIND v(dout0_22) AT=35.025n

.meas tran vdout0_23ck60 FIND v(dout0_23) AT=35.025n

.meas tran vdout0_24ck60 FIND v(dout0_24) AT=35.025n

.meas tran vdout0_25ck60 FIND v(dout0_25) AT=35.025n

.meas tran vdout0_26ck60 FIND v(dout0_26) AT=35.025n

.meas tran vdout0_27ck60 FIND v(dout0_27) AT=35.025n

.meas tran vdout0_28ck60 FIND v(dout0_28) AT=35.025n

.meas tran vdout0_29ck60 FIND v(dout0_29) AT=35.025n

.meas tran vdout0_30ck60 FIND v(dout0_30) AT=35.025n

.meas tran vdout0_31ck60 FIND v(dout0_31) AT=35.025n

.meas tran vdout0_0ck70 FIND v(dout0_0) AT=40.025n

.meas tran vdout0_1ck70 FIND v(dout0_1) AT=40.025n

.meas tran vdout0_2ck70 FIND v(dout0_2) AT=40.025n

.meas tran vdout0_3ck70 FIND v(dout0_3) AT=40.025n

.meas tran vdout0_4ck70 FIND v(dout0_4) AT=40.025n

.meas tran vdout0_5ck70 FIND v(dout0_5) AT=40.025n

.meas tran vdout0_6ck70 FIND v(dout0_6) AT=40.025n

.meas tran vdout0_7ck70 FIND v(dout0_7) AT=40.025n

.meas tran vdout0_8ck70 FIND v(dout0_8) AT=40.025n

.meas tran vdout0_9ck70 FIND v(dout0_9) AT=40.025n

.meas tran vdout0_10ck70 FIND v(dout0_10) AT=40.025n

.meas tran vdout0_11ck70 FIND v(dout0_11) AT=40.025n

.meas tran vdout0_12ck70 FIND v(dout0_12) AT=40.025n

.meas tran vdout0_13ck70 FIND v(dout0_13) AT=40.025n

.meas tran vdout0_14ck70 FIND v(dout0_14) AT=40.025n

.meas tran vdout0_15ck70 FIND v(dout0_15) AT=40.025n

.meas tran vdout0_16ck70 FIND v(dout0_16) AT=40.025n

.meas tran vdout0_17ck70 FIND v(dout0_17) AT=40.025n

.meas tran vdout0_18ck70 FIND v(dout0_18) AT=40.025n

.meas tran vdout0_19ck70 FIND v(dout0_19) AT=40.025n

.meas tran vdout0_20ck70 FIND v(dout0_20) AT=40.025n

.meas tran vdout0_21ck70 FIND v(dout0_21) AT=40.025n

.meas tran vdout0_22ck70 FIND v(dout0_22) AT=40.025n

.meas tran vdout0_23ck70 FIND v(dout0_23) AT=40.025n

.meas tran vdout0_24ck70 FIND v(dout0_24) AT=40.025n

.meas tran vdout0_25ck70 FIND v(dout0_25) AT=40.025n

.meas tran vdout0_26ck70 FIND v(dout0_26) AT=40.025n

.meas tran vdout0_27ck70 FIND v(dout0_27) AT=40.025n

.meas tran vdout0_28ck70 FIND v(dout0_28) AT=40.025n

.meas tran vdout0_29ck70 FIND v(dout0_29) AT=40.025n

.meas tran vdout0_30ck70 FIND v(dout0_30) AT=40.025n

.meas tran vdout0_31ck70 FIND v(dout0_31) AT=40.025n

.meas tran vdout0_0ck100 FIND v(dout0_0) AT=55.025n

.meas tran vdout0_1ck100 FIND v(dout0_1) AT=55.025n

.meas tran vdout0_2ck100 FIND v(dout0_2) AT=55.025n

.meas tran vdout0_3ck100 FIND v(dout0_3) AT=55.025n

.meas tran vdout0_4ck100 FIND v(dout0_4) AT=55.025n

.meas tran vdout0_5ck100 FIND v(dout0_5) AT=55.025n

.meas tran vdout0_6ck100 FIND v(dout0_6) AT=55.025n

.meas tran vdout0_7ck100 FIND v(dout0_7) AT=55.025n

.meas tran vdout0_8ck100 FIND v(dout0_8) AT=55.025n

.meas tran vdout0_9ck100 FIND v(dout0_9) AT=55.025n

.meas tran vdout0_10ck100 FIND v(dout0_10) AT=55.025n

.meas tran vdout0_11ck100 FIND v(dout0_11) AT=55.025n

.meas tran vdout0_12ck100 FIND v(dout0_12) AT=55.025n

.meas tran vdout0_13ck100 FIND v(dout0_13) AT=55.025n

.meas tran vdout0_14ck100 FIND v(dout0_14) AT=55.025n

.meas tran vdout0_15ck100 FIND v(dout0_15) AT=55.025n

.meas tran vdout0_16ck100 FIND v(dout0_16) AT=55.025n

.meas tran vdout0_17ck100 FIND v(dout0_17) AT=55.025n

.meas tran vdout0_18ck100 FIND v(dout0_18) AT=55.025n

.meas tran vdout0_19ck100 FIND v(dout0_19) AT=55.025n

.meas tran vdout0_20ck100 FIND v(dout0_20) AT=55.025n

.meas tran vdout0_21ck100 FIND v(dout0_21) AT=55.025n

.meas tran vdout0_22ck100 FIND v(dout0_22) AT=55.025n

.meas tran vdout0_23ck100 FIND v(dout0_23) AT=55.025n

.meas tran vdout0_24ck100 FIND v(dout0_24) AT=55.025n

.meas tran vdout0_25ck100 FIND v(dout0_25) AT=55.025n

.meas tran vdout0_26ck100 FIND v(dout0_26) AT=55.025n

.meas tran vdout0_27ck100 FIND v(dout0_27) AT=55.025n

.meas tran vdout0_28ck100 FIND v(dout0_28) AT=55.025n

.meas tran vdout0_29ck100 FIND v(dout0_29) AT=55.025n

.meas tran vdout0_30ck100 FIND v(dout0_30) AT=55.025n

.meas tran vdout0_31ck100 FIND v(dout0_31) AT=55.025n

.meas tran vdout0_0ck110 FIND v(dout0_0) AT=60.025n

.meas tran vdout0_1ck110 FIND v(dout0_1) AT=60.025n

.meas tran vdout0_2ck110 FIND v(dout0_2) AT=60.025n

.meas tran vdout0_3ck110 FIND v(dout0_3) AT=60.025n

.meas tran vdout0_4ck110 FIND v(dout0_4) AT=60.025n

.meas tran vdout0_5ck110 FIND v(dout0_5) AT=60.025n

.meas tran vdout0_6ck110 FIND v(dout0_6) AT=60.025n

.meas tran vdout0_7ck110 FIND v(dout0_7) AT=60.025n

.meas tran vdout0_8ck110 FIND v(dout0_8) AT=60.025n

.meas tran vdout0_9ck110 FIND v(dout0_9) AT=60.025n

.meas tran vdout0_10ck110 FIND v(dout0_10) AT=60.025n

.meas tran vdout0_11ck110 FIND v(dout0_11) AT=60.025n

.meas tran vdout0_12ck110 FIND v(dout0_12) AT=60.025n

.meas tran vdout0_13ck110 FIND v(dout0_13) AT=60.025n

.meas tran vdout0_14ck110 FIND v(dout0_14) AT=60.025n

.meas tran vdout0_15ck110 FIND v(dout0_15) AT=60.025n

.meas tran vdout0_16ck110 FIND v(dout0_16) AT=60.025n

.meas tran vdout0_17ck110 FIND v(dout0_17) AT=60.025n

.meas tran vdout0_18ck110 FIND v(dout0_18) AT=60.025n

.meas tran vdout0_19ck110 FIND v(dout0_19) AT=60.025n

.meas tran vdout0_20ck110 FIND v(dout0_20) AT=60.025n

.meas tran vdout0_21ck110 FIND v(dout0_21) AT=60.025n

.meas tran vdout0_22ck110 FIND v(dout0_22) AT=60.025n

.meas tran vdout0_23ck110 FIND v(dout0_23) AT=60.025n

.meas tran vdout0_24ck110 FIND v(dout0_24) AT=60.025n

.meas tran vdout0_25ck110 FIND v(dout0_25) AT=60.025n

.meas tran vdout0_26ck110 FIND v(dout0_26) AT=60.025n

.meas tran vdout0_27ck110 FIND v(dout0_27) AT=60.025n

.meas tran vdout0_28ck110 FIND v(dout0_28) AT=60.025n

.meas tran vdout0_29ck110 FIND v(dout0_29) AT=60.025n

.meas tran vdout0_30ck110 FIND v(dout0_30) AT=60.025n

.meas tran vdout0_31ck110 FIND v(dout0_31) AT=60.025n

.meas tran vdout0_0ck140 FIND v(dout0_0) AT=75.025n

.meas tran vdout0_1ck140 FIND v(dout0_1) AT=75.025n

.meas tran vdout0_2ck140 FIND v(dout0_2) AT=75.025n

.meas tran vdout0_3ck140 FIND v(dout0_3) AT=75.025n

.meas tran vdout0_4ck140 FIND v(dout0_4) AT=75.025n

.meas tran vdout0_5ck140 FIND v(dout0_5) AT=75.025n

.meas tran vdout0_6ck140 FIND v(dout0_6) AT=75.025n

.meas tran vdout0_7ck140 FIND v(dout0_7) AT=75.025n

.meas tran vdout0_8ck140 FIND v(dout0_8) AT=75.025n

.meas tran vdout0_9ck140 FIND v(dout0_9) AT=75.025n

.meas tran vdout0_10ck140 FIND v(dout0_10) AT=75.025n

.meas tran vdout0_11ck140 FIND v(dout0_11) AT=75.025n

.meas tran vdout0_12ck140 FIND v(dout0_12) AT=75.025n

.meas tran vdout0_13ck140 FIND v(dout0_13) AT=75.025n

.meas tran vdout0_14ck140 FIND v(dout0_14) AT=75.025n

.meas tran vdout0_15ck140 FIND v(dout0_15) AT=75.025n

.meas tran vdout0_16ck140 FIND v(dout0_16) AT=75.025n

.meas tran vdout0_17ck140 FIND v(dout0_17) AT=75.025n

.meas tran vdout0_18ck140 FIND v(dout0_18) AT=75.025n

.meas tran vdout0_19ck140 FIND v(dout0_19) AT=75.025n

.meas tran vdout0_20ck140 FIND v(dout0_20) AT=75.025n

.meas tran vdout0_21ck140 FIND v(dout0_21) AT=75.025n

.meas tran vdout0_22ck140 FIND v(dout0_22) AT=75.025n

.meas tran vdout0_23ck140 FIND v(dout0_23) AT=75.025n

.meas tran vdout0_24ck140 FIND v(dout0_24) AT=75.025n

.meas tran vdout0_25ck140 FIND v(dout0_25) AT=75.025n

.meas tran vdout0_26ck140 FIND v(dout0_26) AT=75.025n

.meas tran vdout0_27ck140 FIND v(dout0_27) AT=75.025n

.meas tran vdout0_28ck140 FIND v(dout0_28) AT=75.025n

.meas tran vdout0_29ck140 FIND v(dout0_29) AT=75.025n

.meas tran vdout0_30ck140 FIND v(dout0_30) AT=75.025n

.meas tran vdout0_31ck140 FIND v(dout0_31) AT=75.025n

.meas tran vdout0_0ck160 FIND v(dout0_0) AT=85.025n

.meas tran vdout0_1ck160 FIND v(dout0_1) AT=85.025n

.meas tran vdout0_2ck160 FIND v(dout0_2) AT=85.025n

.meas tran vdout0_3ck160 FIND v(dout0_3) AT=85.025n

.meas tran vdout0_4ck160 FIND v(dout0_4) AT=85.025n

.meas tran vdout0_5ck160 FIND v(dout0_5) AT=85.025n

.meas tran vdout0_6ck160 FIND v(dout0_6) AT=85.025n

.meas tran vdout0_7ck160 FIND v(dout0_7) AT=85.025n

.meas tran vdout0_8ck160 FIND v(dout0_8) AT=85.025n

.meas tran vdout0_9ck160 FIND v(dout0_9) AT=85.025n

.meas tran vdout0_10ck160 FIND v(dout0_10) AT=85.025n

.meas tran vdout0_11ck160 FIND v(dout0_11) AT=85.025n

.meas tran vdout0_12ck160 FIND v(dout0_12) AT=85.025n

.meas tran vdout0_13ck160 FIND v(dout0_13) AT=85.025n

.meas tran vdout0_14ck160 FIND v(dout0_14) AT=85.025n

.meas tran vdout0_15ck160 FIND v(dout0_15) AT=85.025n

.meas tran vdout0_16ck160 FIND v(dout0_16) AT=85.025n

.meas tran vdout0_17ck160 FIND v(dout0_17) AT=85.025n

.meas tran vdout0_18ck160 FIND v(dout0_18) AT=85.025n

.meas tran vdout0_19ck160 FIND v(dout0_19) AT=85.025n

.meas tran vdout0_20ck160 FIND v(dout0_20) AT=85.025n

.meas tran vdout0_21ck160 FIND v(dout0_21) AT=85.025n

.meas tran vdout0_22ck160 FIND v(dout0_22) AT=85.025n

.meas tran vdout0_23ck160 FIND v(dout0_23) AT=85.025n

.meas tran vdout0_24ck160 FIND v(dout0_24) AT=85.025n

.meas tran vdout0_25ck160 FIND v(dout0_25) AT=85.025n

.meas tran vdout0_26ck160 FIND v(dout0_26) AT=85.025n

.meas tran vdout0_27ck160 FIND v(dout0_27) AT=85.025n

.meas tran vdout0_28ck160 FIND v(dout0_28) AT=85.025n

.meas tran vdout0_29ck160 FIND v(dout0_29) AT=85.025n

.meas tran vdout0_30ck160 FIND v(dout0_30) AT=85.025n

.meas tran vdout0_31ck160 FIND v(dout0_31) AT=85.025n

.meas tran vdout0_0ck180 FIND v(dout0_0) AT=95.025n

.meas tran vdout0_1ck180 FIND v(dout0_1) AT=95.025n

.meas tran vdout0_2ck180 FIND v(dout0_2) AT=95.025n

.meas tran vdout0_3ck180 FIND v(dout0_3) AT=95.025n

.meas tran vdout0_4ck180 FIND v(dout0_4) AT=95.025n

.meas tran vdout0_5ck180 FIND v(dout0_5) AT=95.025n

.meas tran vdout0_6ck180 FIND v(dout0_6) AT=95.025n

.meas tran vdout0_7ck180 FIND v(dout0_7) AT=95.025n

.meas tran vdout0_8ck180 FIND v(dout0_8) AT=95.025n

.meas tran vdout0_9ck180 FIND v(dout0_9) AT=95.025n

.meas tran vdout0_10ck180 FIND v(dout0_10) AT=95.025n

.meas tran vdout0_11ck180 FIND v(dout0_11) AT=95.025n

.meas tran vdout0_12ck180 FIND v(dout0_12) AT=95.025n

.meas tran vdout0_13ck180 FIND v(dout0_13) AT=95.025n

.meas tran vdout0_14ck180 FIND v(dout0_14) AT=95.025n

.meas tran vdout0_15ck180 FIND v(dout0_15) AT=95.025n

.meas tran vdout0_16ck180 FIND v(dout0_16) AT=95.025n

.meas tran vdout0_17ck180 FIND v(dout0_17) AT=95.025n

.meas tran vdout0_18ck180 FIND v(dout0_18) AT=95.025n

.meas tran vdout0_19ck180 FIND v(dout0_19) AT=95.025n

.meas tran vdout0_20ck180 FIND v(dout0_20) AT=95.025n

.meas tran vdout0_21ck180 FIND v(dout0_21) AT=95.025n

.meas tran vdout0_22ck180 FIND v(dout0_22) AT=95.025n

.meas tran vdout0_23ck180 FIND v(dout0_23) AT=95.025n

.meas tran vdout0_24ck180 FIND v(dout0_24) AT=95.025n

.meas tran vdout0_25ck180 FIND v(dout0_25) AT=95.025n

.meas tran vdout0_26ck180 FIND v(dout0_26) AT=95.025n

.meas tran vdout0_27ck180 FIND v(dout0_27) AT=95.025n

.meas tran vdout0_28ck180 FIND v(dout0_28) AT=95.025n

.meas tran vdout0_29ck180 FIND v(dout0_29) AT=95.025n

.meas tran vdout0_30ck180 FIND v(dout0_30) AT=95.025n

.meas tran vdout0_31ck180 FIND v(dout0_31) AT=95.025n

.meas tran vdout0_0ck270 FIND v(dout0_0) AT=140.025n

.meas tran vdout0_1ck270 FIND v(dout0_1) AT=140.025n

.meas tran vdout0_2ck270 FIND v(dout0_2) AT=140.025n

.meas tran vdout0_3ck270 FIND v(dout0_3) AT=140.025n

.meas tran vdout0_4ck270 FIND v(dout0_4) AT=140.025n

.meas tran vdout0_5ck270 FIND v(dout0_5) AT=140.025n

.meas tran vdout0_6ck270 FIND v(dout0_6) AT=140.025n

.meas tran vdout0_7ck270 FIND v(dout0_7) AT=140.025n

.meas tran vdout0_8ck270 FIND v(dout0_8) AT=140.025n

.meas tran vdout0_9ck270 FIND v(dout0_9) AT=140.025n

.meas tran vdout0_10ck270 FIND v(dout0_10) AT=140.025n

.meas tran vdout0_11ck270 FIND v(dout0_11) AT=140.025n

.meas tran vdout0_12ck270 FIND v(dout0_12) AT=140.025n

.meas tran vdout0_13ck270 FIND v(dout0_13) AT=140.025n

.meas tran vdout0_14ck270 FIND v(dout0_14) AT=140.025n

.meas tran vdout0_15ck270 FIND v(dout0_15) AT=140.025n

.meas tran vdout0_16ck270 FIND v(dout0_16) AT=140.025n

.meas tran vdout0_17ck270 FIND v(dout0_17) AT=140.025n

.meas tran vdout0_18ck270 FIND v(dout0_18) AT=140.025n

.meas tran vdout0_19ck270 FIND v(dout0_19) AT=140.025n

.meas tran vdout0_20ck270 FIND v(dout0_20) AT=140.025n

.meas tran vdout0_21ck270 FIND v(dout0_21) AT=140.025n

.meas tran vdout0_22ck270 FIND v(dout0_22) AT=140.025n

.meas tran vdout0_23ck270 FIND v(dout0_23) AT=140.025n

.meas tran vdout0_24ck270 FIND v(dout0_24) AT=140.025n

.meas tran vdout0_25ck270 FIND v(dout0_25) AT=140.025n

.meas tran vdout0_26ck270 FIND v(dout0_26) AT=140.025n

.meas tran vdout0_27ck270 FIND v(dout0_27) AT=140.025n

.meas tran vdout0_28ck270 FIND v(dout0_28) AT=140.025n

.meas tran vdout0_29ck270 FIND v(dout0_29) AT=140.025n

.meas tran vdout0_30ck270 FIND v(dout0_30) AT=140.025n

.meas tran vdout0_31ck270 FIND v(dout0_31) AT=140.025n

.meas tran vdout0_0ck280 FIND v(dout0_0) AT=145.025n

.meas tran vdout0_1ck280 FIND v(dout0_1) AT=145.025n

.meas tran vdout0_2ck280 FIND v(dout0_2) AT=145.025n

.meas tran vdout0_3ck280 FIND v(dout0_3) AT=145.025n

.meas tran vdout0_4ck280 FIND v(dout0_4) AT=145.025n

.meas tran vdout0_5ck280 FIND v(dout0_5) AT=145.025n

.meas tran vdout0_6ck280 FIND v(dout0_6) AT=145.025n

.meas tran vdout0_7ck280 FIND v(dout0_7) AT=145.025n

.meas tran vdout0_8ck280 FIND v(dout0_8) AT=145.025n

.meas tran vdout0_9ck280 FIND v(dout0_9) AT=145.025n

.meas tran vdout0_10ck280 FIND v(dout0_10) AT=145.025n

.meas tran vdout0_11ck280 FIND v(dout0_11) AT=145.025n

.meas tran vdout0_12ck280 FIND v(dout0_12) AT=145.025n

.meas tran vdout0_13ck280 FIND v(dout0_13) AT=145.025n

.meas tran vdout0_14ck280 FIND v(dout0_14) AT=145.025n

.meas tran vdout0_15ck280 FIND v(dout0_15) AT=145.025n

.meas tran vdout0_16ck280 FIND v(dout0_16) AT=145.025n

.meas tran vdout0_17ck280 FIND v(dout0_17) AT=145.025n

.meas tran vdout0_18ck280 FIND v(dout0_18) AT=145.025n

.meas tran vdout0_19ck280 FIND v(dout0_19) AT=145.025n

.meas tran vdout0_20ck280 FIND v(dout0_20) AT=145.025n

.meas tran vdout0_21ck280 FIND v(dout0_21) AT=145.025n

.meas tran vdout0_22ck280 FIND v(dout0_22) AT=145.025n

.meas tran vdout0_23ck280 FIND v(dout0_23) AT=145.025n

.meas tran vdout0_24ck280 FIND v(dout0_24) AT=145.025n

.meas tran vdout0_25ck280 FIND v(dout0_25) AT=145.025n

.meas tran vdout0_26ck280 FIND v(dout0_26) AT=145.025n

.meas tran vdout0_27ck280 FIND v(dout0_27) AT=145.025n

.meas tran vdout0_28ck280 FIND v(dout0_28) AT=145.025n

.meas tran vdout0_29ck280 FIND v(dout0_29) AT=145.025n

.meas tran vdout0_30ck280 FIND v(dout0_30) AT=145.025n

.meas tran vdout0_31ck280 FIND v(dout0_31) AT=145.025n

.meas tran vdout0_0ck310 FIND v(dout0_0) AT=160.025n

.meas tran vdout0_1ck310 FIND v(dout0_1) AT=160.025n

.meas tran vdout0_2ck310 FIND v(dout0_2) AT=160.025n

.meas tran vdout0_3ck310 FIND v(dout0_3) AT=160.025n

.meas tran vdout0_4ck310 FIND v(dout0_4) AT=160.025n

.meas tran vdout0_5ck310 FIND v(dout0_5) AT=160.025n

.meas tran vdout0_6ck310 FIND v(dout0_6) AT=160.025n

.meas tran vdout0_7ck310 FIND v(dout0_7) AT=160.025n

.meas tran vdout0_8ck310 FIND v(dout0_8) AT=160.025n

.meas tran vdout0_9ck310 FIND v(dout0_9) AT=160.025n

.meas tran vdout0_10ck310 FIND v(dout0_10) AT=160.025n

.meas tran vdout0_11ck310 FIND v(dout0_11) AT=160.025n

.meas tran vdout0_12ck310 FIND v(dout0_12) AT=160.025n

.meas tran vdout0_13ck310 FIND v(dout0_13) AT=160.025n

.meas tran vdout0_14ck310 FIND v(dout0_14) AT=160.025n

.meas tran vdout0_15ck310 FIND v(dout0_15) AT=160.025n

.meas tran vdout0_16ck310 FIND v(dout0_16) AT=160.025n

.meas tran vdout0_17ck310 FIND v(dout0_17) AT=160.025n

.meas tran vdout0_18ck310 FIND v(dout0_18) AT=160.025n

.meas tran vdout0_19ck310 FIND v(dout0_19) AT=160.025n

.meas tran vdout0_20ck310 FIND v(dout0_20) AT=160.025n

.meas tran vdout0_21ck310 FIND v(dout0_21) AT=160.025n

.meas tran vdout0_22ck310 FIND v(dout0_22) AT=160.025n

.meas tran vdout0_23ck310 FIND v(dout0_23) AT=160.025n

.meas tran vdout0_24ck310 FIND v(dout0_24) AT=160.025n

.meas tran vdout0_25ck310 FIND v(dout0_25) AT=160.025n

.meas tran vdout0_26ck310 FIND v(dout0_26) AT=160.025n

.meas tran vdout0_27ck310 FIND v(dout0_27) AT=160.025n

.meas tran vdout0_28ck310 FIND v(dout0_28) AT=160.025n

.meas tran vdout0_29ck310 FIND v(dout0_29) AT=160.025n

.meas tran vdout0_30ck310 FIND v(dout0_30) AT=160.025n

.meas tran vdout0_31ck310 FIND v(dout0_31) AT=160.025n

.meas tran vdout0_0ck380 FIND v(dout0_0) AT=195.025n

.meas tran vdout0_1ck380 FIND v(dout0_1) AT=195.025n

.meas tran vdout0_2ck380 FIND v(dout0_2) AT=195.025n

.meas tran vdout0_3ck380 FIND v(dout0_3) AT=195.025n

.meas tran vdout0_4ck380 FIND v(dout0_4) AT=195.025n

.meas tran vdout0_5ck380 FIND v(dout0_5) AT=195.025n

.meas tran vdout0_6ck380 FIND v(dout0_6) AT=195.025n

.meas tran vdout0_7ck380 FIND v(dout0_7) AT=195.025n

.meas tran vdout0_8ck380 FIND v(dout0_8) AT=195.025n

.meas tran vdout0_9ck380 FIND v(dout0_9) AT=195.025n

.meas tran vdout0_10ck380 FIND v(dout0_10) AT=195.025n

.meas tran vdout0_11ck380 FIND v(dout0_11) AT=195.025n

.meas tran vdout0_12ck380 FIND v(dout0_12) AT=195.025n

.meas tran vdout0_13ck380 FIND v(dout0_13) AT=195.025n

.meas tran vdout0_14ck380 FIND v(dout0_14) AT=195.025n

.meas tran vdout0_15ck380 FIND v(dout0_15) AT=195.025n

.meas tran vdout0_16ck380 FIND v(dout0_16) AT=195.025n

.meas tran vdout0_17ck380 FIND v(dout0_17) AT=195.025n

.meas tran vdout0_18ck380 FIND v(dout0_18) AT=195.025n

.meas tran vdout0_19ck380 FIND v(dout0_19) AT=195.025n

.meas tran vdout0_20ck380 FIND v(dout0_20) AT=195.025n

.meas tran vdout0_21ck380 FIND v(dout0_21) AT=195.025n

.meas tran vdout0_22ck380 FIND v(dout0_22) AT=195.025n

.meas tran vdout0_23ck380 FIND v(dout0_23) AT=195.025n

.meas tran vdout0_24ck380 FIND v(dout0_24) AT=195.025n

.meas tran vdout0_25ck380 FIND v(dout0_25) AT=195.025n

.meas tran vdout0_26ck380 FIND v(dout0_26) AT=195.025n

.meas tran vdout0_27ck380 FIND v(dout0_27) AT=195.025n

.meas tran vdout0_28ck380 FIND v(dout0_28) AT=195.025n

.meas tran vdout0_29ck380 FIND v(dout0_29) AT=195.025n

.meas tran vdout0_30ck380 FIND v(dout0_30) AT=195.025n

.meas tran vdout0_31ck380 FIND v(dout0_31) AT=195.025n

.meas tran vdout0_0ck430 FIND v(dout0_0) AT=220.025n

.meas tran vdout0_1ck430 FIND v(dout0_1) AT=220.025n

.meas tran vdout0_2ck430 FIND v(dout0_2) AT=220.025n

.meas tran vdout0_3ck430 FIND v(dout0_3) AT=220.025n

.meas tran vdout0_4ck430 FIND v(dout0_4) AT=220.025n

.meas tran vdout0_5ck430 FIND v(dout0_5) AT=220.025n

.meas tran vdout0_6ck430 FIND v(dout0_6) AT=220.025n

.meas tran vdout0_7ck430 FIND v(dout0_7) AT=220.025n

.meas tran vdout0_8ck430 FIND v(dout0_8) AT=220.025n

.meas tran vdout0_9ck430 FIND v(dout0_9) AT=220.025n

.meas tran vdout0_10ck430 FIND v(dout0_10) AT=220.025n

.meas tran vdout0_11ck430 FIND v(dout0_11) AT=220.025n

.meas tran vdout0_12ck430 FIND v(dout0_12) AT=220.025n

.meas tran vdout0_13ck430 FIND v(dout0_13) AT=220.025n

.meas tran vdout0_14ck430 FIND v(dout0_14) AT=220.025n

.meas tran vdout0_15ck430 FIND v(dout0_15) AT=220.025n

.meas tran vdout0_16ck430 FIND v(dout0_16) AT=220.025n

.meas tran vdout0_17ck430 FIND v(dout0_17) AT=220.025n

.meas tran vdout0_18ck430 FIND v(dout0_18) AT=220.025n

.meas tran vdout0_19ck430 FIND v(dout0_19) AT=220.025n

.meas tran vdout0_20ck430 FIND v(dout0_20) AT=220.025n

.meas tran vdout0_21ck430 FIND v(dout0_21) AT=220.025n

.meas tran vdout0_22ck430 FIND v(dout0_22) AT=220.025n

.meas tran vdout0_23ck430 FIND v(dout0_23) AT=220.025n

.meas tran vdout0_24ck430 FIND v(dout0_24) AT=220.025n

.meas tran vdout0_25ck430 FIND v(dout0_25) AT=220.025n

.meas tran vdout0_26ck430 FIND v(dout0_26) AT=220.025n

.meas tran vdout0_27ck430 FIND v(dout0_27) AT=220.025n

.meas tran vdout0_28ck430 FIND v(dout0_28) AT=220.025n

.meas tran vdout0_29ck430 FIND v(dout0_29) AT=220.025n

.meas tran vdout0_30ck430 FIND v(dout0_30) AT=220.025n

.meas tran vdout0_31ck430 FIND v(dout0_31) AT=220.025n

.meas tran vdout0_0ck440 FIND v(dout0_0) AT=225.025n

.meas tran vdout0_1ck440 FIND v(dout0_1) AT=225.025n

.meas tran vdout0_2ck440 FIND v(dout0_2) AT=225.025n

.meas tran vdout0_3ck440 FIND v(dout0_3) AT=225.025n

.meas tran vdout0_4ck440 FIND v(dout0_4) AT=225.025n

.meas tran vdout0_5ck440 FIND v(dout0_5) AT=225.025n

.meas tran vdout0_6ck440 FIND v(dout0_6) AT=225.025n

.meas tran vdout0_7ck440 FIND v(dout0_7) AT=225.025n

.meas tran vdout0_8ck440 FIND v(dout0_8) AT=225.025n

.meas tran vdout0_9ck440 FIND v(dout0_9) AT=225.025n

.meas tran vdout0_10ck440 FIND v(dout0_10) AT=225.025n

.meas tran vdout0_11ck440 FIND v(dout0_11) AT=225.025n

.meas tran vdout0_12ck440 FIND v(dout0_12) AT=225.025n

.meas tran vdout0_13ck440 FIND v(dout0_13) AT=225.025n

.meas tran vdout0_14ck440 FIND v(dout0_14) AT=225.025n

.meas tran vdout0_15ck440 FIND v(dout0_15) AT=225.025n

.meas tran vdout0_16ck440 FIND v(dout0_16) AT=225.025n

.meas tran vdout0_17ck440 FIND v(dout0_17) AT=225.025n

.meas tran vdout0_18ck440 FIND v(dout0_18) AT=225.025n

.meas tran vdout0_19ck440 FIND v(dout0_19) AT=225.025n

.meas tran vdout0_20ck440 FIND v(dout0_20) AT=225.025n

.meas tran vdout0_21ck440 FIND v(dout0_21) AT=225.025n

.meas tran vdout0_22ck440 FIND v(dout0_22) AT=225.025n

.meas tran vdout0_23ck440 FIND v(dout0_23) AT=225.025n

.meas tran vdout0_24ck440 FIND v(dout0_24) AT=225.025n

.meas tran vdout0_25ck440 FIND v(dout0_25) AT=225.025n

.meas tran vdout0_26ck440 FIND v(dout0_26) AT=225.025n

.meas tran vdout0_27ck440 FIND v(dout0_27) AT=225.025n

.meas tran vdout0_28ck440 FIND v(dout0_28) AT=225.025n

.meas tran vdout0_29ck440 FIND v(dout0_29) AT=225.025n

.meas tran vdout0_30ck440 FIND v(dout0_30) AT=225.025n

.meas tran vdout0_31ck440 FIND v(dout0_31) AT=225.025n

.meas tran vdout0_0ck450 FIND v(dout0_0) AT=230.025n

.meas tran vdout0_1ck450 FIND v(dout0_1) AT=230.025n

.meas tran vdout0_2ck450 FIND v(dout0_2) AT=230.025n

.meas tran vdout0_3ck450 FIND v(dout0_3) AT=230.025n

.meas tran vdout0_4ck450 FIND v(dout0_4) AT=230.025n

.meas tran vdout0_5ck450 FIND v(dout0_5) AT=230.025n

.meas tran vdout0_6ck450 FIND v(dout0_6) AT=230.025n

.meas tran vdout0_7ck450 FIND v(dout0_7) AT=230.025n

.meas tran vdout0_8ck450 FIND v(dout0_8) AT=230.025n

.meas tran vdout0_9ck450 FIND v(dout0_9) AT=230.025n

.meas tran vdout0_10ck450 FIND v(dout0_10) AT=230.025n

.meas tran vdout0_11ck450 FIND v(dout0_11) AT=230.025n

.meas tran vdout0_12ck450 FIND v(dout0_12) AT=230.025n

.meas tran vdout0_13ck450 FIND v(dout0_13) AT=230.025n

.meas tran vdout0_14ck450 FIND v(dout0_14) AT=230.025n

.meas tran vdout0_15ck450 FIND v(dout0_15) AT=230.025n

.meas tran vdout0_16ck450 FIND v(dout0_16) AT=230.025n

.meas tran vdout0_17ck450 FIND v(dout0_17) AT=230.025n

.meas tran vdout0_18ck450 FIND v(dout0_18) AT=230.025n

.meas tran vdout0_19ck450 FIND v(dout0_19) AT=230.025n

.meas tran vdout0_20ck450 FIND v(dout0_20) AT=230.025n

.meas tran vdout0_21ck450 FIND v(dout0_21) AT=230.025n

.meas tran vdout0_22ck450 FIND v(dout0_22) AT=230.025n

.meas tran vdout0_23ck450 FIND v(dout0_23) AT=230.025n

.meas tran vdout0_24ck450 FIND v(dout0_24) AT=230.025n

.meas tran vdout0_25ck450 FIND v(dout0_25) AT=230.025n

.meas tran vdout0_26ck450 FIND v(dout0_26) AT=230.025n

.meas tran vdout0_27ck450 FIND v(dout0_27) AT=230.025n

.meas tran vdout0_28ck450 FIND v(dout0_28) AT=230.025n

.meas tran vdout0_29ck450 FIND v(dout0_29) AT=230.025n

.meas tran vdout0_30ck450 FIND v(dout0_30) AT=230.025n

.meas tran vdout0_31ck450 FIND v(dout0_31) AT=230.025n

.meas tran vdout0_0ck470 FIND v(dout0_0) AT=240.025n

.meas tran vdout0_1ck470 FIND v(dout0_1) AT=240.025n

.meas tran vdout0_2ck470 FIND v(dout0_2) AT=240.025n

.meas tran vdout0_3ck470 FIND v(dout0_3) AT=240.025n

.meas tran vdout0_4ck470 FIND v(dout0_4) AT=240.025n

.meas tran vdout0_5ck470 FIND v(dout0_5) AT=240.025n

.meas tran vdout0_6ck470 FIND v(dout0_6) AT=240.025n

.meas tran vdout0_7ck470 FIND v(dout0_7) AT=240.025n

.meas tran vdout0_8ck470 FIND v(dout0_8) AT=240.025n

.meas tran vdout0_9ck470 FIND v(dout0_9) AT=240.025n

.meas tran vdout0_10ck470 FIND v(dout0_10) AT=240.025n

.meas tran vdout0_11ck470 FIND v(dout0_11) AT=240.025n

.meas tran vdout0_12ck470 FIND v(dout0_12) AT=240.025n

.meas tran vdout0_13ck470 FIND v(dout0_13) AT=240.025n

.meas tran vdout0_14ck470 FIND v(dout0_14) AT=240.025n

.meas tran vdout0_15ck470 FIND v(dout0_15) AT=240.025n

.meas tran vdout0_16ck470 FIND v(dout0_16) AT=240.025n

.meas tran vdout0_17ck470 FIND v(dout0_17) AT=240.025n

.meas tran vdout0_18ck470 FIND v(dout0_18) AT=240.025n

.meas tran vdout0_19ck470 FIND v(dout0_19) AT=240.025n

.meas tran vdout0_20ck470 FIND v(dout0_20) AT=240.025n

.meas tran vdout0_21ck470 FIND v(dout0_21) AT=240.025n

.meas tran vdout0_22ck470 FIND v(dout0_22) AT=240.025n

.meas tran vdout0_23ck470 FIND v(dout0_23) AT=240.025n

.meas tran vdout0_24ck470 FIND v(dout0_24) AT=240.025n

.meas tran vdout0_25ck470 FIND v(dout0_25) AT=240.025n

.meas tran vdout0_26ck470 FIND v(dout0_26) AT=240.025n

.meas tran vdout0_27ck470 FIND v(dout0_27) AT=240.025n

.meas tran vdout0_28ck470 FIND v(dout0_28) AT=240.025n

.meas tran vdout0_29ck470 FIND v(dout0_29) AT=240.025n

.meas tran vdout0_30ck470 FIND v(dout0_30) AT=240.025n

.meas tran vdout0_31ck470 FIND v(dout0_31) AT=240.025n

.meas tran vdout0_0ck480 FIND v(dout0_0) AT=245.025n

.meas tran vdout0_1ck480 FIND v(dout0_1) AT=245.025n

.meas tran vdout0_2ck480 FIND v(dout0_2) AT=245.025n

.meas tran vdout0_3ck480 FIND v(dout0_3) AT=245.025n

.meas tran vdout0_4ck480 FIND v(dout0_4) AT=245.025n

.meas tran vdout0_5ck480 FIND v(dout0_5) AT=245.025n

.meas tran vdout0_6ck480 FIND v(dout0_6) AT=245.025n

.meas tran vdout0_7ck480 FIND v(dout0_7) AT=245.025n

.meas tran vdout0_8ck480 FIND v(dout0_8) AT=245.025n

.meas tran vdout0_9ck480 FIND v(dout0_9) AT=245.025n

.meas tran vdout0_10ck480 FIND v(dout0_10) AT=245.025n

.meas tran vdout0_11ck480 FIND v(dout0_11) AT=245.025n

.meas tran vdout0_12ck480 FIND v(dout0_12) AT=245.025n

.meas tran vdout0_13ck480 FIND v(dout0_13) AT=245.025n

.meas tran vdout0_14ck480 FIND v(dout0_14) AT=245.025n

.meas tran vdout0_15ck480 FIND v(dout0_15) AT=245.025n

.meas tran vdout0_16ck480 FIND v(dout0_16) AT=245.025n

.meas tran vdout0_17ck480 FIND v(dout0_17) AT=245.025n

.meas tran vdout0_18ck480 FIND v(dout0_18) AT=245.025n

.meas tran vdout0_19ck480 FIND v(dout0_19) AT=245.025n

.meas tran vdout0_20ck480 FIND v(dout0_20) AT=245.025n

.meas tran vdout0_21ck480 FIND v(dout0_21) AT=245.025n

.meas tran vdout0_22ck480 FIND v(dout0_22) AT=245.025n

.meas tran vdout0_23ck480 FIND v(dout0_23) AT=245.025n

.meas tran vdout0_24ck480 FIND v(dout0_24) AT=245.025n

.meas tran vdout0_25ck480 FIND v(dout0_25) AT=245.025n

.meas tran vdout0_26ck480 FIND v(dout0_26) AT=245.025n

.meas tran vdout0_27ck480 FIND v(dout0_27) AT=245.025n

.meas tran vdout0_28ck480 FIND v(dout0_28) AT=245.025n

.meas tran vdout0_29ck480 FIND v(dout0_29) AT=245.025n

.meas tran vdout0_30ck480 FIND v(dout0_30) AT=245.025n

.meas tran vdout0_31ck480 FIND v(dout0_31) AT=245.025n

.meas tran vdout0_0ck500 FIND v(dout0_0) AT=255.025n

.meas tran vdout0_1ck500 FIND v(dout0_1) AT=255.025n

.meas tran vdout0_2ck500 FIND v(dout0_2) AT=255.025n

.meas tran vdout0_3ck500 FIND v(dout0_3) AT=255.025n

.meas tran vdout0_4ck500 FIND v(dout0_4) AT=255.025n

.meas tran vdout0_5ck500 FIND v(dout0_5) AT=255.025n

.meas tran vdout0_6ck500 FIND v(dout0_6) AT=255.025n

.meas tran vdout0_7ck500 FIND v(dout0_7) AT=255.025n

.meas tran vdout0_8ck500 FIND v(dout0_8) AT=255.025n

.meas tran vdout0_9ck500 FIND v(dout0_9) AT=255.025n

.meas tran vdout0_10ck500 FIND v(dout0_10) AT=255.025n

.meas tran vdout0_11ck500 FIND v(dout0_11) AT=255.025n

.meas tran vdout0_12ck500 FIND v(dout0_12) AT=255.025n

.meas tran vdout0_13ck500 FIND v(dout0_13) AT=255.025n

.meas tran vdout0_14ck500 FIND v(dout0_14) AT=255.025n

.meas tran vdout0_15ck500 FIND v(dout0_15) AT=255.025n

.meas tran vdout0_16ck500 FIND v(dout0_16) AT=255.025n

.meas tran vdout0_17ck500 FIND v(dout0_17) AT=255.025n

.meas tran vdout0_18ck500 FIND v(dout0_18) AT=255.025n

.meas tran vdout0_19ck500 FIND v(dout0_19) AT=255.025n

.meas tran vdout0_20ck500 FIND v(dout0_20) AT=255.025n

.meas tran vdout0_21ck500 FIND v(dout0_21) AT=255.025n

.meas tran vdout0_22ck500 FIND v(dout0_22) AT=255.025n

.meas tran vdout0_23ck500 FIND v(dout0_23) AT=255.025n

.meas tran vdout0_24ck500 FIND v(dout0_24) AT=255.025n

.meas tran vdout0_25ck500 FIND v(dout0_25) AT=255.025n

.meas tran vdout0_26ck500 FIND v(dout0_26) AT=255.025n

.meas tran vdout0_27ck500 FIND v(dout0_27) AT=255.025n

.meas tran vdout0_28ck500 FIND v(dout0_28) AT=255.025n

.meas tran vdout0_29ck500 FIND v(dout0_29) AT=255.025n

.meas tran vdout0_30ck500 FIND v(dout0_30) AT=255.025n

.meas tran vdout0_31ck500 FIND v(dout0_31) AT=255.025n

.meas tran vdout0_0ck510 FIND v(dout0_0) AT=260.025n

.meas tran vdout0_1ck510 FIND v(dout0_1) AT=260.025n

.meas tran vdout0_2ck510 FIND v(dout0_2) AT=260.025n

.meas tran vdout0_3ck510 FIND v(dout0_3) AT=260.025n

.meas tran vdout0_4ck510 FIND v(dout0_4) AT=260.025n

.meas tran vdout0_5ck510 FIND v(dout0_5) AT=260.025n

.meas tran vdout0_6ck510 FIND v(dout0_6) AT=260.025n

.meas tran vdout0_7ck510 FIND v(dout0_7) AT=260.025n

.meas tran vdout0_8ck510 FIND v(dout0_8) AT=260.025n

.meas tran vdout0_9ck510 FIND v(dout0_9) AT=260.025n

.meas tran vdout0_10ck510 FIND v(dout0_10) AT=260.025n

.meas tran vdout0_11ck510 FIND v(dout0_11) AT=260.025n

.meas tran vdout0_12ck510 FIND v(dout0_12) AT=260.025n

.meas tran vdout0_13ck510 FIND v(dout0_13) AT=260.025n

.meas tran vdout0_14ck510 FIND v(dout0_14) AT=260.025n

.meas tran vdout0_15ck510 FIND v(dout0_15) AT=260.025n

.meas tran vdout0_16ck510 FIND v(dout0_16) AT=260.025n

.meas tran vdout0_17ck510 FIND v(dout0_17) AT=260.025n

.meas tran vdout0_18ck510 FIND v(dout0_18) AT=260.025n

.meas tran vdout0_19ck510 FIND v(dout0_19) AT=260.025n

.meas tran vdout0_20ck510 FIND v(dout0_20) AT=260.025n

.meas tran vdout0_21ck510 FIND v(dout0_21) AT=260.025n

.meas tran vdout0_22ck510 FIND v(dout0_22) AT=260.025n

.meas tran vdout0_23ck510 FIND v(dout0_23) AT=260.025n

.meas tran vdout0_24ck510 FIND v(dout0_24) AT=260.025n

.meas tran vdout0_25ck510 FIND v(dout0_25) AT=260.025n

.meas tran vdout0_26ck510 FIND v(dout0_26) AT=260.025n

.meas tran vdout0_27ck510 FIND v(dout0_27) AT=260.025n

.meas tran vdout0_28ck510 FIND v(dout0_28) AT=260.025n

.meas tran vdout0_29ck510 FIND v(dout0_29) AT=260.025n

.meas tran vdout0_30ck510 FIND v(dout0_30) AT=260.025n

.meas tran vdout0_31ck510 FIND v(dout0_31) AT=260.025n

.meas tran vdout0_0ck560 FIND v(dout0_0) AT=285.025n

.meas tran vdout0_1ck560 FIND v(dout0_1) AT=285.025n

.meas tran vdout0_2ck560 FIND v(dout0_2) AT=285.025n

.meas tran vdout0_3ck560 FIND v(dout0_3) AT=285.025n

.meas tran vdout0_4ck560 FIND v(dout0_4) AT=285.025n

.meas tran vdout0_5ck560 FIND v(dout0_5) AT=285.025n

.meas tran vdout0_6ck560 FIND v(dout0_6) AT=285.025n

.meas tran vdout0_7ck560 FIND v(dout0_7) AT=285.025n

.meas tran vdout0_8ck560 FIND v(dout0_8) AT=285.025n

.meas tran vdout0_9ck560 FIND v(dout0_9) AT=285.025n

.meas tran vdout0_10ck560 FIND v(dout0_10) AT=285.025n

.meas tran vdout0_11ck560 FIND v(dout0_11) AT=285.025n

.meas tran vdout0_12ck560 FIND v(dout0_12) AT=285.025n

.meas tran vdout0_13ck560 FIND v(dout0_13) AT=285.025n

.meas tran vdout0_14ck560 FIND v(dout0_14) AT=285.025n

.meas tran vdout0_15ck560 FIND v(dout0_15) AT=285.025n

.meas tran vdout0_16ck560 FIND v(dout0_16) AT=285.025n

.meas tran vdout0_17ck560 FIND v(dout0_17) AT=285.025n

.meas tran vdout0_18ck560 FIND v(dout0_18) AT=285.025n

.meas tran vdout0_19ck560 FIND v(dout0_19) AT=285.025n

.meas tran vdout0_20ck560 FIND v(dout0_20) AT=285.025n

.meas tran vdout0_21ck560 FIND v(dout0_21) AT=285.025n

.meas tran vdout0_22ck560 FIND v(dout0_22) AT=285.025n

.meas tran vdout0_23ck560 FIND v(dout0_23) AT=285.025n

.meas tran vdout0_24ck560 FIND v(dout0_24) AT=285.025n

.meas tran vdout0_25ck560 FIND v(dout0_25) AT=285.025n

.meas tran vdout0_26ck560 FIND v(dout0_26) AT=285.025n

.meas tran vdout0_27ck560 FIND v(dout0_27) AT=285.025n

.meas tran vdout0_28ck560 FIND v(dout0_28) AT=285.025n

.meas tran vdout0_29ck560 FIND v(dout0_29) AT=285.025n

.meas tran vdout0_30ck560 FIND v(dout0_30) AT=285.025n

.meas tran vdout0_31ck560 FIND v(dout0_31) AT=285.025n

.meas tran vdout0_0ck580 FIND v(dout0_0) AT=295.025n

.meas tran vdout0_1ck580 FIND v(dout0_1) AT=295.025n

.meas tran vdout0_2ck580 FIND v(dout0_2) AT=295.025n

.meas tran vdout0_3ck580 FIND v(dout0_3) AT=295.025n

.meas tran vdout0_4ck580 FIND v(dout0_4) AT=295.025n

.meas tran vdout0_5ck580 FIND v(dout0_5) AT=295.025n

.meas tran vdout0_6ck580 FIND v(dout0_6) AT=295.025n

.meas tran vdout0_7ck580 FIND v(dout0_7) AT=295.025n

.meas tran vdout0_8ck580 FIND v(dout0_8) AT=295.025n

.meas tran vdout0_9ck580 FIND v(dout0_9) AT=295.025n

.meas tran vdout0_10ck580 FIND v(dout0_10) AT=295.025n

.meas tran vdout0_11ck580 FIND v(dout0_11) AT=295.025n

.meas tran vdout0_12ck580 FIND v(dout0_12) AT=295.025n

.meas tran vdout0_13ck580 FIND v(dout0_13) AT=295.025n

.meas tran vdout0_14ck580 FIND v(dout0_14) AT=295.025n

.meas tran vdout0_15ck580 FIND v(dout0_15) AT=295.025n

.meas tran vdout0_16ck580 FIND v(dout0_16) AT=295.025n

.meas tran vdout0_17ck580 FIND v(dout0_17) AT=295.025n

.meas tran vdout0_18ck580 FIND v(dout0_18) AT=295.025n

.meas tran vdout0_19ck580 FIND v(dout0_19) AT=295.025n

.meas tran vdout0_20ck580 FIND v(dout0_20) AT=295.025n

.meas tran vdout0_21ck580 FIND v(dout0_21) AT=295.025n

.meas tran vdout0_22ck580 FIND v(dout0_22) AT=295.025n

.meas tran vdout0_23ck580 FIND v(dout0_23) AT=295.025n

.meas tran vdout0_24ck580 FIND v(dout0_24) AT=295.025n

.meas tran vdout0_25ck580 FIND v(dout0_25) AT=295.025n

.meas tran vdout0_26ck580 FIND v(dout0_26) AT=295.025n

.meas tran vdout0_27ck580 FIND v(dout0_27) AT=295.025n

.meas tran vdout0_28ck580 FIND v(dout0_28) AT=295.025n

.meas tran vdout0_29ck580 FIND v(dout0_29) AT=295.025n

.meas tran vdout0_30ck580 FIND v(dout0_30) AT=295.025n

.meas tran vdout0_31ck580 FIND v(dout0_31) AT=295.025n

.meas tran vdout0_0ck600 FIND v(dout0_0) AT=305.025n

.meas tran vdout0_1ck600 FIND v(dout0_1) AT=305.025n

.meas tran vdout0_2ck600 FIND v(dout0_2) AT=305.025n

.meas tran vdout0_3ck600 FIND v(dout0_3) AT=305.025n

.meas tran vdout0_4ck600 FIND v(dout0_4) AT=305.025n

.meas tran vdout0_5ck600 FIND v(dout0_5) AT=305.025n

.meas tran vdout0_6ck600 FIND v(dout0_6) AT=305.025n

.meas tran vdout0_7ck600 FIND v(dout0_7) AT=305.025n

.meas tran vdout0_8ck600 FIND v(dout0_8) AT=305.025n

.meas tran vdout0_9ck600 FIND v(dout0_9) AT=305.025n

.meas tran vdout0_10ck600 FIND v(dout0_10) AT=305.025n

.meas tran vdout0_11ck600 FIND v(dout0_11) AT=305.025n

.meas tran vdout0_12ck600 FIND v(dout0_12) AT=305.025n

.meas tran vdout0_13ck600 FIND v(dout0_13) AT=305.025n

.meas tran vdout0_14ck600 FIND v(dout0_14) AT=305.025n

.meas tran vdout0_15ck600 FIND v(dout0_15) AT=305.025n

.meas tran vdout0_16ck600 FIND v(dout0_16) AT=305.025n

.meas tran vdout0_17ck600 FIND v(dout0_17) AT=305.025n

.meas tran vdout0_18ck600 FIND v(dout0_18) AT=305.025n

.meas tran vdout0_19ck600 FIND v(dout0_19) AT=305.025n

.meas tran vdout0_20ck600 FIND v(dout0_20) AT=305.025n

.meas tran vdout0_21ck600 FIND v(dout0_21) AT=305.025n

.meas tran vdout0_22ck600 FIND v(dout0_22) AT=305.025n

.meas tran vdout0_23ck600 FIND v(dout0_23) AT=305.025n

.meas tran vdout0_24ck600 FIND v(dout0_24) AT=305.025n

.meas tran vdout0_25ck600 FIND v(dout0_25) AT=305.025n

.meas tran vdout0_26ck600 FIND v(dout0_26) AT=305.025n

.meas tran vdout0_27ck600 FIND v(dout0_27) AT=305.025n

.meas tran vdout0_28ck600 FIND v(dout0_28) AT=305.025n

.meas tran vdout0_29ck600 FIND v(dout0_29) AT=305.025n

.meas tran vdout0_30ck600 FIND v(dout0_30) AT=305.025n

.meas tran vdout0_31ck600 FIND v(dout0_31) AT=305.025n

.meas tran vdout0_0ck660 FIND v(dout0_0) AT=335.025n

.meas tran vdout0_1ck660 FIND v(dout0_1) AT=335.025n

.meas tran vdout0_2ck660 FIND v(dout0_2) AT=335.025n

.meas tran vdout0_3ck660 FIND v(dout0_3) AT=335.025n

.meas tran vdout0_4ck660 FIND v(dout0_4) AT=335.025n

.meas tran vdout0_5ck660 FIND v(dout0_5) AT=335.025n

.meas tran vdout0_6ck660 FIND v(dout0_6) AT=335.025n

.meas tran vdout0_7ck660 FIND v(dout0_7) AT=335.025n

.meas tran vdout0_8ck660 FIND v(dout0_8) AT=335.025n

.meas tran vdout0_9ck660 FIND v(dout0_9) AT=335.025n

.meas tran vdout0_10ck660 FIND v(dout0_10) AT=335.025n

.meas tran vdout0_11ck660 FIND v(dout0_11) AT=335.025n

.meas tran vdout0_12ck660 FIND v(dout0_12) AT=335.025n

.meas tran vdout0_13ck660 FIND v(dout0_13) AT=335.025n

.meas tran vdout0_14ck660 FIND v(dout0_14) AT=335.025n

.meas tran vdout0_15ck660 FIND v(dout0_15) AT=335.025n

.meas tran vdout0_16ck660 FIND v(dout0_16) AT=335.025n

.meas tran vdout0_17ck660 FIND v(dout0_17) AT=335.025n

.meas tran vdout0_18ck660 FIND v(dout0_18) AT=335.025n

.meas tran vdout0_19ck660 FIND v(dout0_19) AT=335.025n

.meas tran vdout0_20ck660 FIND v(dout0_20) AT=335.025n

.meas tran vdout0_21ck660 FIND v(dout0_21) AT=335.025n

.meas tran vdout0_22ck660 FIND v(dout0_22) AT=335.025n

.meas tran vdout0_23ck660 FIND v(dout0_23) AT=335.025n

.meas tran vdout0_24ck660 FIND v(dout0_24) AT=335.025n

.meas tran vdout0_25ck660 FIND v(dout0_25) AT=335.025n

.meas tran vdout0_26ck660 FIND v(dout0_26) AT=335.025n

.meas tran vdout0_27ck660 FIND v(dout0_27) AT=335.025n

.meas tran vdout0_28ck660 FIND v(dout0_28) AT=335.025n

.meas tran vdout0_29ck660 FIND v(dout0_29) AT=335.025n

.meas tran vdout0_30ck660 FIND v(dout0_30) AT=335.025n

.meas tran vdout0_31ck660 FIND v(dout0_31) AT=335.025n

.meas tran vdout0_0ck690 FIND v(dout0_0) AT=350.025n

.meas tran vdout0_1ck690 FIND v(dout0_1) AT=350.025n

.meas tran vdout0_2ck690 FIND v(dout0_2) AT=350.025n

.meas tran vdout0_3ck690 FIND v(dout0_3) AT=350.025n

.meas tran vdout0_4ck690 FIND v(dout0_4) AT=350.025n

.meas tran vdout0_5ck690 FIND v(dout0_5) AT=350.025n

.meas tran vdout0_6ck690 FIND v(dout0_6) AT=350.025n

.meas tran vdout0_7ck690 FIND v(dout0_7) AT=350.025n

.meas tran vdout0_8ck690 FIND v(dout0_8) AT=350.025n

.meas tran vdout0_9ck690 FIND v(dout0_9) AT=350.025n

.meas tran vdout0_10ck690 FIND v(dout0_10) AT=350.025n

.meas tran vdout0_11ck690 FIND v(dout0_11) AT=350.025n

.meas tran vdout0_12ck690 FIND v(dout0_12) AT=350.025n

.meas tran vdout0_13ck690 FIND v(dout0_13) AT=350.025n

.meas tran vdout0_14ck690 FIND v(dout0_14) AT=350.025n

.meas tran vdout0_15ck690 FIND v(dout0_15) AT=350.025n

.meas tran vdout0_16ck690 FIND v(dout0_16) AT=350.025n

.meas tran vdout0_17ck690 FIND v(dout0_17) AT=350.025n

.meas tran vdout0_18ck690 FIND v(dout0_18) AT=350.025n

.meas tran vdout0_19ck690 FIND v(dout0_19) AT=350.025n

.meas tran vdout0_20ck690 FIND v(dout0_20) AT=350.025n

.meas tran vdout0_21ck690 FIND v(dout0_21) AT=350.025n

.meas tran vdout0_22ck690 FIND v(dout0_22) AT=350.025n

.meas tran vdout0_23ck690 FIND v(dout0_23) AT=350.025n

.meas tran vdout0_24ck690 FIND v(dout0_24) AT=350.025n

.meas tran vdout0_25ck690 FIND v(dout0_25) AT=350.025n

.meas tran vdout0_26ck690 FIND v(dout0_26) AT=350.025n

.meas tran vdout0_27ck690 FIND v(dout0_27) AT=350.025n

.meas tran vdout0_28ck690 FIND v(dout0_28) AT=350.025n

.meas tran vdout0_29ck690 FIND v(dout0_29) AT=350.025n

.meas tran vdout0_30ck690 FIND v(dout0_30) AT=350.025n

.meas tran vdout0_31ck690 FIND v(dout0_31) AT=350.025n

.meas tran vdout0_0ck720 FIND v(dout0_0) AT=365.025n

.meas tran vdout0_1ck720 FIND v(dout0_1) AT=365.025n

.meas tran vdout0_2ck720 FIND v(dout0_2) AT=365.025n

.meas tran vdout0_3ck720 FIND v(dout0_3) AT=365.025n

.meas tran vdout0_4ck720 FIND v(dout0_4) AT=365.025n

.meas tran vdout0_5ck720 FIND v(dout0_5) AT=365.025n

.meas tran vdout0_6ck720 FIND v(dout0_6) AT=365.025n

.meas tran vdout0_7ck720 FIND v(dout0_7) AT=365.025n

.meas tran vdout0_8ck720 FIND v(dout0_8) AT=365.025n

.meas tran vdout0_9ck720 FIND v(dout0_9) AT=365.025n

.meas tran vdout0_10ck720 FIND v(dout0_10) AT=365.025n

.meas tran vdout0_11ck720 FIND v(dout0_11) AT=365.025n

.meas tran vdout0_12ck720 FIND v(dout0_12) AT=365.025n

.meas tran vdout0_13ck720 FIND v(dout0_13) AT=365.025n

.meas tran vdout0_14ck720 FIND v(dout0_14) AT=365.025n

.meas tran vdout0_15ck720 FIND v(dout0_15) AT=365.025n

.meas tran vdout0_16ck720 FIND v(dout0_16) AT=365.025n

.meas tran vdout0_17ck720 FIND v(dout0_17) AT=365.025n

.meas tran vdout0_18ck720 FIND v(dout0_18) AT=365.025n

.meas tran vdout0_19ck720 FIND v(dout0_19) AT=365.025n

.meas tran vdout0_20ck720 FIND v(dout0_20) AT=365.025n

.meas tran vdout0_21ck720 FIND v(dout0_21) AT=365.025n

.meas tran vdout0_22ck720 FIND v(dout0_22) AT=365.025n

.meas tran vdout0_23ck720 FIND v(dout0_23) AT=365.025n

.meas tran vdout0_24ck720 FIND v(dout0_24) AT=365.025n

.meas tran vdout0_25ck720 FIND v(dout0_25) AT=365.025n

.meas tran vdout0_26ck720 FIND v(dout0_26) AT=365.025n

.meas tran vdout0_27ck720 FIND v(dout0_27) AT=365.025n

.meas tran vdout0_28ck720 FIND v(dout0_28) AT=365.025n

.meas tran vdout0_29ck720 FIND v(dout0_29) AT=365.025n

.meas tran vdout0_30ck720 FIND v(dout0_30) AT=365.025n

.meas tran vdout0_31ck720 FIND v(dout0_31) AT=365.025n

.meas tran vdout0_0ck730 FIND v(dout0_0) AT=370.025n

.meas tran vdout0_1ck730 FIND v(dout0_1) AT=370.025n

.meas tran vdout0_2ck730 FIND v(dout0_2) AT=370.025n

.meas tran vdout0_3ck730 FIND v(dout0_3) AT=370.025n

.meas tran vdout0_4ck730 FIND v(dout0_4) AT=370.025n

.meas tran vdout0_5ck730 FIND v(dout0_5) AT=370.025n

.meas tran vdout0_6ck730 FIND v(dout0_6) AT=370.025n

.meas tran vdout0_7ck730 FIND v(dout0_7) AT=370.025n

.meas tran vdout0_8ck730 FIND v(dout0_8) AT=370.025n

.meas tran vdout0_9ck730 FIND v(dout0_9) AT=370.025n

.meas tran vdout0_10ck730 FIND v(dout0_10) AT=370.025n

.meas tran vdout0_11ck730 FIND v(dout0_11) AT=370.025n

.meas tran vdout0_12ck730 FIND v(dout0_12) AT=370.025n

.meas tran vdout0_13ck730 FIND v(dout0_13) AT=370.025n

.meas tran vdout0_14ck730 FIND v(dout0_14) AT=370.025n

.meas tran vdout0_15ck730 FIND v(dout0_15) AT=370.025n

.meas tran vdout0_16ck730 FIND v(dout0_16) AT=370.025n

.meas tran vdout0_17ck730 FIND v(dout0_17) AT=370.025n

.meas tran vdout0_18ck730 FIND v(dout0_18) AT=370.025n

.meas tran vdout0_19ck730 FIND v(dout0_19) AT=370.025n

.meas tran vdout0_20ck730 FIND v(dout0_20) AT=370.025n

.meas tran vdout0_21ck730 FIND v(dout0_21) AT=370.025n

.meas tran vdout0_22ck730 FIND v(dout0_22) AT=370.025n

.meas tran vdout0_23ck730 FIND v(dout0_23) AT=370.025n

.meas tran vdout0_24ck730 FIND v(dout0_24) AT=370.025n

.meas tran vdout0_25ck730 FIND v(dout0_25) AT=370.025n

.meas tran vdout0_26ck730 FIND v(dout0_26) AT=370.025n

.meas tran vdout0_27ck730 FIND v(dout0_27) AT=370.025n

.meas tran vdout0_28ck730 FIND v(dout0_28) AT=370.025n

.meas tran vdout0_29ck730 FIND v(dout0_29) AT=370.025n

.meas tran vdout0_30ck730 FIND v(dout0_30) AT=370.025n

.meas tran vdout0_31ck730 FIND v(dout0_31) AT=370.025n

.meas tran vdout0_0ck750 FIND v(dout0_0) AT=380.025n

.meas tran vdout0_1ck750 FIND v(dout0_1) AT=380.025n

.meas tran vdout0_2ck750 FIND v(dout0_2) AT=380.025n

.meas tran vdout0_3ck750 FIND v(dout0_3) AT=380.025n

.meas tran vdout0_4ck750 FIND v(dout0_4) AT=380.025n

.meas tran vdout0_5ck750 FIND v(dout0_5) AT=380.025n

.meas tran vdout0_6ck750 FIND v(dout0_6) AT=380.025n

.meas tran vdout0_7ck750 FIND v(dout0_7) AT=380.025n

.meas tran vdout0_8ck750 FIND v(dout0_8) AT=380.025n

.meas tran vdout0_9ck750 FIND v(dout0_9) AT=380.025n

.meas tran vdout0_10ck750 FIND v(dout0_10) AT=380.025n

.meas tran vdout0_11ck750 FIND v(dout0_11) AT=380.025n

.meas tran vdout0_12ck750 FIND v(dout0_12) AT=380.025n

.meas tran vdout0_13ck750 FIND v(dout0_13) AT=380.025n

.meas tran vdout0_14ck750 FIND v(dout0_14) AT=380.025n

.meas tran vdout0_15ck750 FIND v(dout0_15) AT=380.025n

.meas tran vdout0_16ck750 FIND v(dout0_16) AT=380.025n

.meas tran vdout0_17ck750 FIND v(dout0_17) AT=380.025n

.meas tran vdout0_18ck750 FIND v(dout0_18) AT=380.025n

.meas tran vdout0_19ck750 FIND v(dout0_19) AT=380.025n

.meas tran vdout0_20ck750 FIND v(dout0_20) AT=380.025n

.meas tran vdout0_21ck750 FIND v(dout0_21) AT=380.025n

.meas tran vdout0_22ck750 FIND v(dout0_22) AT=380.025n

.meas tran vdout0_23ck750 FIND v(dout0_23) AT=380.025n

.meas tran vdout0_24ck750 FIND v(dout0_24) AT=380.025n

.meas tran vdout0_25ck750 FIND v(dout0_25) AT=380.025n

.meas tran vdout0_26ck750 FIND v(dout0_26) AT=380.025n

.meas tran vdout0_27ck750 FIND v(dout0_27) AT=380.025n

.meas tran vdout0_28ck750 FIND v(dout0_28) AT=380.025n

.meas tran vdout0_29ck750 FIND v(dout0_29) AT=380.025n

.meas tran vdout0_30ck750 FIND v(dout0_30) AT=380.025n

.meas tran vdout0_31ck750 FIND v(dout0_31) AT=380.025n

.meas tran vdout0_0ck770 FIND v(dout0_0) AT=390.025n

.meas tran vdout0_1ck770 FIND v(dout0_1) AT=390.025n

.meas tran vdout0_2ck770 FIND v(dout0_2) AT=390.025n

.meas tran vdout0_3ck770 FIND v(dout0_3) AT=390.025n

.meas tran vdout0_4ck770 FIND v(dout0_4) AT=390.025n

.meas tran vdout0_5ck770 FIND v(dout0_5) AT=390.025n

.meas tran vdout0_6ck770 FIND v(dout0_6) AT=390.025n

.meas tran vdout0_7ck770 FIND v(dout0_7) AT=390.025n

.meas tran vdout0_8ck770 FIND v(dout0_8) AT=390.025n

.meas tran vdout0_9ck770 FIND v(dout0_9) AT=390.025n

.meas tran vdout0_10ck770 FIND v(dout0_10) AT=390.025n

.meas tran vdout0_11ck770 FIND v(dout0_11) AT=390.025n

.meas tran vdout0_12ck770 FIND v(dout0_12) AT=390.025n

.meas tran vdout0_13ck770 FIND v(dout0_13) AT=390.025n

.meas tran vdout0_14ck770 FIND v(dout0_14) AT=390.025n

.meas tran vdout0_15ck770 FIND v(dout0_15) AT=390.025n

.meas tran vdout0_16ck770 FIND v(dout0_16) AT=390.025n

.meas tran vdout0_17ck770 FIND v(dout0_17) AT=390.025n

.meas tran vdout0_18ck770 FIND v(dout0_18) AT=390.025n

.meas tran vdout0_19ck770 FIND v(dout0_19) AT=390.025n

.meas tran vdout0_20ck770 FIND v(dout0_20) AT=390.025n

.meas tran vdout0_21ck770 FIND v(dout0_21) AT=390.025n

.meas tran vdout0_22ck770 FIND v(dout0_22) AT=390.025n

.meas tran vdout0_23ck770 FIND v(dout0_23) AT=390.025n

.meas tran vdout0_24ck770 FIND v(dout0_24) AT=390.025n

.meas tran vdout0_25ck770 FIND v(dout0_25) AT=390.025n

.meas tran vdout0_26ck770 FIND v(dout0_26) AT=390.025n

.meas tran vdout0_27ck770 FIND v(dout0_27) AT=390.025n

.meas tran vdout0_28ck770 FIND v(dout0_28) AT=390.025n

.meas tran vdout0_29ck770 FIND v(dout0_29) AT=390.025n

.meas tran vdout0_30ck770 FIND v(dout0_30) AT=390.025n

.meas tran vdout0_31ck770 FIND v(dout0_31) AT=390.025n

.meas tran vdout0_0ck780 FIND v(dout0_0) AT=395.025n

.meas tran vdout0_1ck780 FIND v(dout0_1) AT=395.025n

.meas tran vdout0_2ck780 FIND v(dout0_2) AT=395.025n

.meas tran vdout0_3ck780 FIND v(dout0_3) AT=395.025n

.meas tran vdout0_4ck780 FIND v(dout0_4) AT=395.025n

.meas tran vdout0_5ck780 FIND v(dout0_5) AT=395.025n

.meas tran vdout0_6ck780 FIND v(dout0_6) AT=395.025n

.meas tran vdout0_7ck780 FIND v(dout0_7) AT=395.025n

.meas tran vdout0_8ck780 FIND v(dout0_8) AT=395.025n

.meas tran vdout0_9ck780 FIND v(dout0_9) AT=395.025n

.meas tran vdout0_10ck780 FIND v(dout0_10) AT=395.025n

.meas tran vdout0_11ck780 FIND v(dout0_11) AT=395.025n

.meas tran vdout0_12ck780 FIND v(dout0_12) AT=395.025n

.meas tran vdout0_13ck780 FIND v(dout0_13) AT=395.025n

.meas tran vdout0_14ck780 FIND v(dout0_14) AT=395.025n

.meas tran vdout0_15ck780 FIND v(dout0_15) AT=395.025n

.meas tran vdout0_16ck780 FIND v(dout0_16) AT=395.025n

.meas tran vdout0_17ck780 FIND v(dout0_17) AT=395.025n

.meas tran vdout0_18ck780 FIND v(dout0_18) AT=395.025n

.meas tran vdout0_19ck780 FIND v(dout0_19) AT=395.025n

.meas tran vdout0_20ck780 FIND v(dout0_20) AT=395.025n

.meas tran vdout0_21ck780 FIND v(dout0_21) AT=395.025n

.meas tran vdout0_22ck780 FIND v(dout0_22) AT=395.025n

.meas tran vdout0_23ck780 FIND v(dout0_23) AT=395.025n

.meas tran vdout0_24ck780 FIND v(dout0_24) AT=395.025n

.meas tran vdout0_25ck780 FIND v(dout0_25) AT=395.025n

.meas tran vdout0_26ck780 FIND v(dout0_26) AT=395.025n

.meas tran vdout0_27ck780 FIND v(dout0_27) AT=395.025n

.meas tran vdout0_28ck780 FIND v(dout0_28) AT=395.025n

.meas tran vdout0_29ck780 FIND v(dout0_29) AT=395.025n

.meas tran vdout0_30ck780 FIND v(dout0_30) AT=395.025n

.meas tran vdout0_31ck780 FIND v(dout0_31) AT=395.025n

.meas tran vdout0_0ck790 FIND v(dout0_0) AT=400.025n

.meas tran vdout0_1ck790 FIND v(dout0_1) AT=400.025n

.meas tran vdout0_2ck790 FIND v(dout0_2) AT=400.025n

.meas tran vdout0_3ck790 FIND v(dout0_3) AT=400.025n

.meas tran vdout0_4ck790 FIND v(dout0_4) AT=400.025n

.meas tran vdout0_5ck790 FIND v(dout0_5) AT=400.025n

.meas tran vdout0_6ck790 FIND v(dout0_6) AT=400.025n

.meas tran vdout0_7ck790 FIND v(dout0_7) AT=400.025n

.meas tran vdout0_8ck790 FIND v(dout0_8) AT=400.025n

.meas tran vdout0_9ck790 FIND v(dout0_9) AT=400.025n

.meas tran vdout0_10ck790 FIND v(dout0_10) AT=400.025n

.meas tran vdout0_11ck790 FIND v(dout0_11) AT=400.025n

.meas tran vdout0_12ck790 FIND v(dout0_12) AT=400.025n

.meas tran vdout0_13ck790 FIND v(dout0_13) AT=400.025n

.meas tran vdout0_14ck790 FIND v(dout0_14) AT=400.025n

.meas tran vdout0_15ck790 FIND v(dout0_15) AT=400.025n

.meas tran vdout0_16ck790 FIND v(dout0_16) AT=400.025n

.meas tran vdout0_17ck790 FIND v(dout0_17) AT=400.025n

.meas tran vdout0_18ck790 FIND v(dout0_18) AT=400.025n

.meas tran vdout0_19ck790 FIND v(dout0_19) AT=400.025n

.meas tran vdout0_20ck790 FIND v(dout0_20) AT=400.025n

.meas tran vdout0_21ck790 FIND v(dout0_21) AT=400.025n

.meas tran vdout0_22ck790 FIND v(dout0_22) AT=400.025n

.meas tran vdout0_23ck790 FIND v(dout0_23) AT=400.025n

.meas tran vdout0_24ck790 FIND v(dout0_24) AT=400.025n

.meas tran vdout0_25ck790 FIND v(dout0_25) AT=400.025n

.meas tran vdout0_26ck790 FIND v(dout0_26) AT=400.025n

.meas tran vdout0_27ck790 FIND v(dout0_27) AT=400.025n

.meas tran vdout0_28ck790 FIND v(dout0_28) AT=400.025n

.meas tran vdout0_29ck790 FIND v(dout0_29) AT=400.025n

.meas tran vdout0_30ck790 FIND v(dout0_30) AT=400.025n

.meas tran vdout0_31ck790 FIND v(dout0_31) AT=400.025n

.meas tran vdout0_0ck810 FIND v(dout0_0) AT=410.025n

.meas tran vdout0_1ck810 FIND v(dout0_1) AT=410.025n

.meas tran vdout0_2ck810 FIND v(dout0_2) AT=410.025n

.meas tran vdout0_3ck810 FIND v(dout0_3) AT=410.025n

.meas tran vdout0_4ck810 FIND v(dout0_4) AT=410.025n

.meas tran vdout0_5ck810 FIND v(dout0_5) AT=410.025n

.meas tran vdout0_6ck810 FIND v(dout0_6) AT=410.025n

.meas tran vdout0_7ck810 FIND v(dout0_7) AT=410.025n

.meas tran vdout0_8ck810 FIND v(dout0_8) AT=410.025n

.meas tran vdout0_9ck810 FIND v(dout0_9) AT=410.025n

.meas tran vdout0_10ck810 FIND v(dout0_10) AT=410.025n

.meas tran vdout0_11ck810 FIND v(dout0_11) AT=410.025n

.meas tran vdout0_12ck810 FIND v(dout0_12) AT=410.025n

.meas tran vdout0_13ck810 FIND v(dout0_13) AT=410.025n

.meas tran vdout0_14ck810 FIND v(dout0_14) AT=410.025n

.meas tran vdout0_15ck810 FIND v(dout0_15) AT=410.025n

.meas tran vdout0_16ck810 FIND v(dout0_16) AT=410.025n

.meas tran vdout0_17ck810 FIND v(dout0_17) AT=410.025n

.meas tran vdout0_18ck810 FIND v(dout0_18) AT=410.025n

.meas tran vdout0_19ck810 FIND v(dout0_19) AT=410.025n

.meas tran vdout0_20ck810 FIND v(dout0_20) AT=410.025n

.meas tran vdout0_21ck810 FIND v(dout0_21) AT=410.025n

.meas tran vdout0_22ck810 FIND v(dout0_22) AT=410.025n

.meas tran vdout0_23ck810 FIND v(dout0_23) AT=410.025n

.meas tran vdout0_24ck810 FIND v(dout0_24) AT=410.025n

.meas tran vdout0_25ck810 FIND v(dout0_25) AT=410.025n

.meas tran vdout0_26ck810 FIND v(dout0_26) AT=410.025n

.meas tran vdout0_27ck810 FIND v(dout0_27) AT=410.025n

.meas tran vdout0_28ck810 FIND v(dout0_28) AT=410.025n

.meas tran vdout0_29ck810 FIND v(dout0_29) AT=410.025n

.meas tran vdout0_30ck810 FIND v(dout0_30) AT=410.025n

.meas tran vdout0_31ck810 FIND v(dout0_31) AT=410.025n

.meas tran vdout0_0ck830 FIND v(dout0_0) AT=420.025n

.meas tran vdout0_1ck830 FIND v(dout0_1) AT=420.025n

.meas tran vdout0_2ck830 FIND v(dout0_2) AT=420.025n

.meas tran vdout0_3ck830 FIND v(dout0_3) AT=420.025n

.meas tran vdout0_4ck830 FIND v(dout0_4) AT=420.025n

.meas tran vdout0_5ck830 FIND v(dout0_5) AT=420.025n

.meas tran vdout0_6ck830 FIND v(dout0_6) AT=420.025n

.meas tran vdout0_7ck830 FIND v(dout0_7) AT=420.025n

.meas tran vdout0_8ck830 FIND v(dout0_8) AT=420.025n

.meas tran vdout0_9ck830 FIND v(dout0_9) AT=420.025n

.meas tran vdout0_10ck830 FIND v(dout0_10) AT=420.025n

.meas tran vdout0_11ck830 FIND v(dout0_11) AT=420.025n

.meas tran vdout0_12ck830 FIND v(dout0_12) AT=420.025n

.meas tran vdout0_13ck830 FIND v(dout0_13) AT=420.025n

.meas tran vdout0_14ck830 FIND v(dout0_14) AT=420.025n

.meas tran vdout0_15ck830 FIND v(dout0_15) AT=420.025n

.meas tran vdout0_16ck830 FIND v(dout0_16) AT=420.025n

.meas tran vdout0_17ck830 FIND v(dout0_17) AT=420.025n

.meas tran vdout0_18ck830 FIND v(dout0_18) AT=420.025n

.meas tran vdout0_19ck830 FIND v(dout0_19) AT=420.025n

.meas tran vdout0_20ck830 FIND v(dout0_20) AT=420.025n

.meas tran vdout0_21ck830 FIND v(dout0_21) AT=420.025n

.meas tran vdout0_22ck830 FIND v(dout0_22) AT=420.025n

.meas tran vdout0_23ck830 FIND v(dout0_23) AT=420.025n

.meas tran vdout0_24ck830 FIND v(dout0_24) AT=420.025n

.meas tran vdout0_25ck830 FIND v(dout0_25) AT=420.025n

.meas tran vdout0_26ck830 FIND v(dout0_26) AT=420.025n

.meas tran vdout0_27ck830 FIND v(dout0_27) AT=420.025n

.meas tran vdout0_28ck830 FIND v(dout0_28) AT=420.025n

.meas tran vdout0_29ck830 FIND v(dout0_29) AT=420.025n

.meas tran vdout0_30ck830 FIND v(dout0_30) AT=420.025n

.meas tran vdout0_31ck830 FIND v(dout0_31) AT=420.025n

.meas tran vdout0_0ck840 FIND v(dout0_0) AT=425.025n

.meas tran vdout0_1ck840 FIND v(dout0_1) AT=425.025n

.meas tran vdout0_2ck840 FIND v(dout0_2) AT=425.025n

.meas tran vdout0_3ck840 FIND v(dout0_3) AT=425.025n

.meas tran vdout0_4ck840 FIND v(dout0_4) AT=425.025n

.meas tran vdout0_5ck840 FIND v(dout0_5) AT=425.025n

.meas tran vdout0_6ck840 FIND v(dout0_6) AT=425.025n

.meas tran vdout0_7ck840 FIND v(dout0_7) AT=425.025n

.meas tran vdout0_8ck840 FIND v(dout0_8) AT=425.025n

.meas tran vdout0_9ck840 FIND v(dout0_9) AT=425.025n

.meas tran vdout0_10ck840 FIND v(dout0_10) AT=425.025n

.meas tran vdout0_11ck840 FIND v(dout0_11) AT=425.025n

.meas tran vdout0_12ck840 FIND v(dout0_12) AT=425.025n

.meas tran vdout0_13ck840 FIND v(dout0_13) AT=425.025n

.meas tran vdout0_14ck840 FIND v(dout0_14) AT=425.025n

.meas tran vdout0_15ck840 FIND v(dout0_15) AT=425.025n

.meas tran vdout0_16ck840 FIND v(dout0_16) AT=425.025n

.meas tran vdout0_17ck840 FIND v(dout0_17) AT=425.025n

.meas tran vdout0_18ck840 FIND v(dout0_18) AT=425.025n

.meas tran vdout0_19ck840 FIND v(dout0_19) AT=425.025n

.meas tran vdout0_20ck840 FIND v(dout0_20) AT=425.025n

.meas tran vdout0_21ck840 FIND v(dout0_21) AT=425.025n

.meas tran vdout0_22ck840 FIND v(dout0_22) AT=425.025n

.meas tran vdout0_23ck840 FIND v(dout0_23) AT=425.025n

.meas tran vdout0_24ck840 FIND v(dout0_24) AT=425.025n

.meas tran vdout0_25ck840 FIND v(dout0_25) AT=425.025n

.meas tran vdout0_26ck840 FIND v(dout0_26) AT=425.025n

.meas tran vdout0_27ck840 FIND v(dout0_27) AT=425.025n

.meas tran vdout0_28ck840 FIND v(dout0_28) AT=425.025n

.meas tran vdout0_29ck840 FIND v(dout0_29) AT=425.025n

.meas tran vdout0_30ck840 FIND v(dout0_30) AT=425.025n

.meas tran vdout0_31ck840 FIND v(dout0_31) AT=425.025n

.meas tran vdout0_0ck850 FIND v(dout0_0) AT=430.025n

.meas tran vdout0_1ck850 FIND v(dout0_1) AT=430.025n

.meas tran vdout0_2ck850 FIND v(dout0_2) AT=430.025n

.meas tran vdout0_3ck850 FIND v(dout0_3) AT=430.025n

.meas tran vdout0_4ck850 FIND v(dout0_4) AT=430.025n

.meas tran vdout0_5ck850 FIND v(dout0_5) AT=430.025n

.meas tran vdout0_6ck850 FIND v(dout0_6) AT=430.025n

.meas tran vdout0_7ck850 FIND v(dout0_7) AT=430.025n

.meas tran vdout0_8ck850 FIND v(dout0_8) AT=430.025n

.meas tran vdout0_9ck850 FIND v(dout0_9) AT=430.025n

.meas tran vdout0_10ck850 FIND v(dout0_10) AT=430.025n

.meas tran vdout0_11ck850 FIND v(dout0_11) AT=430.025n

.meas tran vdout0_12ck850 FIND v(dout0_12) AT=430.025n

.meas tran vdout0_13ck850 FIND v(dout0_13) AT=430.025n

.meas tran vdout0_14ck850 FIND v(dout0_14) AT=430.025n

.meas tran vdout0_15ck850 FIND v(dout0_15) AT=430.025n

.meas tran vdout0_16ck850 FIND v(dout0_16) AT=430.025n

.meas tran vdout0_17ck850 FIND v(dout0_17) AT=430.025n

.meas tran vdout0_18ck850 FIND v(dout0_18) AT=430.025n

.meas tran vdout0_19ck850 FIND v(dout0_19) AT=430.025n

.meas tran vdout0_20ck850 FIND v(dout0_20) AT=430.025n

.meas tran vdout0_21ck850 FIND v(dout0_21) AT=430.025n

.meas tran vdout0_22ck850 FIND v(dout0_22) AT=430.025n

.meas tran vdout0_23ck850 FIND v(dout0_23) AT=430.025n

.meas tran vdout0_24ck850 FIND v(dout0_24) AT=430.025n

.meas tran vdout0_25ck850 FIND v(dout0_25) AT=430.025n

.meas tran vdout0_26ck850 FIND v(dout0_26) AT=430.025n

.meas tran vdout0_27ck850 FIND v(dout0_27) AT=430.025n

.meas tran vdout0_28ck850 FIND v(dout0_28) AT=430.025n

.meas tran vdout0_29ck850 FIND v(dout0_29) AT=430.025n

.meas tran vdout0_30ck850 FIND v(dout0_30) AT=430.025n

.meas tran vdout0_31ck850 FIND v(dout0_31) AT=430.025n

.meas tran vdout0_0ck880 FIND v(dout0_0) AT=445.025n

.meas tran vdout0_1ck880 FIND v(dout0_1) AT=445.025n

.meas tran vdout0_2ck880 FIND v(dout0_2) AT=445.025n

.meas tran vdout0_3ck880 FIND v(dout0_3) AT=445.025n

.meas tran vdout0_4ck880 FIND v(dout0_4) AT=445.025n

.meas tran vdout0_5ck880 FIND v(dout0_5) AT=445.025n

.meas tran vdout0_6ck880 FIND v(dout0_6) AT=445.025n

.meas tran vdout0_7ck880 FIND v(dout0_7) AT=445.025n

.meas tran vdout0_8ck880 FIND v(dout0_8) AT=445.025n

.meas tran vdout0_9ck880 FIND v(dout0_9) AT=445.025n

.meas tran vdout0_10ck880 FIND v(dout0_10) AT=445.025n

.meas tran vdout0_11ck880 FIND v(dout0_11) AT=445.025n

.meas tran vdout0_12ck880 FIND v(dout0_12) AT=445.025n

.meas tran vdout0_13ck880 FIND v(dout0_13) AT=445.025n

.meas tran vdout0_14ck880 FIND v(dout0_14) AT=445.025n

.meas tran vdout0_15ck880 FIND v(dout0_15) AT=445.025n

.meas tran vdout0_16ck880 FIND v(dout0_16) AT=445.025n

.meas tran vdout0_17ck880 FIND v(dout0_17) AT=445.025n

.meas tran vdout0_18ck880 FIND v(dout0_18) AT=445.025n

.meas tran vdout0_19ck880 FIND v(dout0_19) AT=445.025n

.meas tran vdout0_20ck880 FIND v(dout0_20) AT=445.025n

.meas tran vdout0_21ck880 FIND v(dout0_21) AT=445.025n

.meas tran vdout0_22ck880 FIND v(dout0_22) AT=445.025n

.meas tran vdout0_23ck880 FIND v(dout0_23) AT=445.025n

.meas tran vdout0_24ck880 FIND v(dout0_24) AT=445.025n

.meas tran vdout0_25ck880 FIND v(dout0_25) AT=445.025n

.meas tran vdout0_26ck880 FIND v(dout0_26) AT=445.025n

.meas tran vdout0_27ck880 FIND v(dout0_27) AT=445.025n

.meas tran vdout0_28ck880 FIND v(dout0_28) AT=445.025n

.meas tran vdout0_29ck880 FIND v(dout0_29) AT=445.025n

.meas tran vdout0_30ck880 FIND v(dout0_30) AT=445.025n

.meas tran vdout0_31ck880 FIND v(dout0_31) AT=445.025n

.meas tran vdout0_0ck940 FIND v(dout0_0) AT=475.025n

.meas tran vdout0_1ck940 FIND v(dout0_1) AT=475.025n

.meas tran vdout0_2ck940 FIND v(dout0_2) AT=475.025n

.meas tran vdout0_3ck940 FIND v(dout0_3) AT=475.025n

.meas tran vdout0_4ck940 FIND v(dout0_4) AT=475.025n

.meas tran vdout0_5ck940 FIND v(dout0_5) AT=475.025n

.meas tran vdout0_6ck940 FIND v(dout0_6) AT=475.025n

.meas tran vdout0_7ck940 FIND v(dout0_7) AT=475.025n

.meas tran vdout0_8ck940 FIND v(dout0_8) AT=475.025n

.meas tran vdout0_9ck940 FIND v(dout0_9) AT=475.025n

.meas tran vdout0_10ck940 FIND v(dout0_10) AT=475.025n

.meas tran vdout0_11ck940 FIND v(dout0_11) AT=475.025n

.meas tran vdout0_12ck940 FIND v(dout0_12) AT=475.025n

.meas tran vdout0_13ck940 FIND v(dout0_13) AT=475.025n

.meas tran vdout0_14ck940 FIND v(dout0_14) AT=475.025n

.meas tran vdout0_15ck940 FIND v(dout0_15) AT=475.025n

.meas tran vdout0_16ck940 FIND v(dout0_16) AT=475.025n

.meas tran vdout0_17ck940 FIND v(dout0_17) AT=475.025n

.meas tran vdout0_18ck940 FIND v(dout0_18) AT=475.025n

.meas tran vdout0_19ck940 FIND v(dout0_19) AT=475.025n

.meas tran vdout0_20ck940 FIND v(dout0_20) AT=475.025n

.meas tran vdout0_21ck940 FIND v(dout0_21) AT=475.025n

.meas tran vdout0_22ck940 FIND v(dout0_22) AT=475.025n

.meas tran vdout0_23ck940 FIND v(dout0_23) AT=475.025n

.meas tran vdout0_24ck940 FIND v(dout0_24) AT=475.025n

.meas tran vdout0_25ck940 FIND v(dout0_25) AT=475.025n

.meas tran vdout0_26ck940 FIND v(dout0_26) AT=475.025n

.meas tran vdout0_27ck940 FIND v(dout0_27) AT=475.025n

.meas tran vdout0_28ck940 FIND v(dout0_28) AT=475.025n

.meas tran vdout0_29ck940 FIND v(dout0_29) AT=475.025n

.meas tran vdout0_30ck940 FIND v(dout0_30) AT=475.025n

.meas tran vdout0_31ck940 FIND v(dout0_31) AT=475.025n

.meas tran vdout0_0ck950 FIND v(dout0_0) AT=480.025n

.meas tran vdout0_1ck950 FIND v(dout0_1) AT=480.025n

.meas tran vdout0_2ck950 FIND v(dout0_2) AT=480.025n

.meas tran vdout0_3ck950 FIND v(dout0_3) AT=480.025n

.meas tran vdout0_4ck950 FIND v(dout0_4) AT=480.025n

.meas tran vdout0_5ck950 FIND v(dout0_5) AT=480.025n

.meas tran vdout0_6ck950 FIND v(dout0_6) AT=480.025n

.meas tran vdout0_7ck950 FIND v(dout0_7) AT=480.025n

.meas tran vdout0_8ck950 FIND v(dout0_8) AT=480.025n

.meas tran vdout0_9ck950 FIND v(dout0_9) AT=480.025n

.meas tran vdout0_10ck950 FIND v(dout0_10) AT=480.025n

.meas tran vdout0_11ck950 FIND v(dout0_11) AT=480.025n

.meas tran vdout0_12ck950 FIND v(dout0_12) AT=480.025n

.meas tran vdout0_13ck950 FIND v(dout0_13) AT=480.025n

.meas tran vdout0_14ck950 FIND v(dout0_14) AT=480.025n

.meas tran vdout0_15ck950 FIND v(dout0_15) AT=480.025n

.meas tran vdout0_16ck950 FIND v(dout0_16) AT=480.025n

.meas tran vdout0_17ck950 FIND v(dout0_17) AT=480.025n

.meas tran vdout0_18ck950 FIND v(dout0_18) AT=480.025n

.meas tran vdout0_19ck950 FIND v(dout0_19) AT=480.025n

.meas tran vdout0_20ck950 FIND v(dout0_20) AT=480.025n

.meas tran vdout0_21ck950 FIND v(dout0_21) AT=480.025n

.meas tran vdout0_22ck950 FIND v(dout0_22) AT=480.025n

.meas tran vdout0_23ck950 FIND v(dout0_23) AT=480.025n

.meas tran vdout0_24ck950 FIND v(dout0_24) AT=480.025n

.meas tran vdout0_25ck950 FIND v(dout0_25) AT=480.025n

.meas tran vdout0_26ck950 FIND v(dout0_26) AT=480.025n

.meas tran vdout0_27ck950 FIND v(dout0_27) AT=480.025n

.meas tran vdout0_28ck950 FIND v(dout0_28) AT=480.025n

.meas tran vdout0_29ck950 FIND v(dout0_29) AT=480.025n

.meas tran vdout0_30ck950 FIND v(dout0_30) AT=480.025n

.meas tran vdout0_31ck950 FIND v(dout0_31) AT=480.025n

.meas tran vdout0_0ck980 FIND v(dout0_0) AT=495.025n

.meas tran vdout0_1ck980 FIND v(dout0_1) AT=495.025n

.meas tran vdout0_2ck980 FIND v(dout0_2) AT=495.025n

.meas tran vdout0_3ck980 FIND v(dout0_3) AT=495.025n

.meas tran vdout0_4ck980 FIND v(dout0_4) AT=495.025n

.meas tran vdout0_5ck980 FIND v(dout0_5) AT=495.025n

.meas tran vdout0_6ck980 FIND v(dout0_6) AT=495.025n

.meas tran vdout0_7ck980 FIND v(dout0_7) AT=495.025n

.meas tran vdout0_8ck980 FIND v(dout0_8) AT=495.025n

.meas tran vdout0_9ck980 FIND v(dout0_9) AT=495.025n

.meas tran vdout0_10ck980 FIND v(dout0_10) AT=495.025n

.meas tran vdout0_11ck980 FIND v(dout0_11) AT=495.025n

.meas tran vdout0_12ck980 FIND v(dout0_12) AT=495.025n

.meas tran vdout0_13ck980 FIND v(dout0_13) AT=495.025n

.meas tran vdout0_14ck980 FIND v(dout0_14) AT=495.025n

.meas tran vdout0_15ck980 FIND v(dout0_15) AT=495.025n

.meas tran vdout0_16ck980 FIND v(dout0_16) AT=495.025n

.meas tran vdout0_17ck980 FIND v(dout0_17) AT=495.025n

.meas tran vdout0_18ck980 FIND v(dout0_18) AT=495.025n

.meas tran vdout0_19ck980 FIND v(dout0_19) AT=495.025n

.meas tran vdout0_20ck980 FIND v(dout0_20) AT=495.025n

.meas tran vdout0_21ck980 FIND v(dout0_21) AT=495.025n

.meas tran vdout0_22ck980 FIND v(dout0_22) AT=495.025n

.meas tran vdout0_23ck980 FIND v(dout0_23) AT=495.025n

.meas tran vdout0_24ck980 FIND v(dout0_24) AT=495.025n

.meas tran vdout0_25ck980 FIND v(dout0_25) AT=495.025n

.meas tran vdout0_26ck980 FIND v(dout0_26) AT=495.025n

.meas tran vdout0_27ck980 FIND v(dout0_27) AT=495.025n

.meas tran vdout0_28ck980 FIND v(dout0_28) AT=495.025n

.meas tran vdout0_29ck980 FIND v(dout0_29) AT=495.025n

.meas tran vdout0_30ck980 FIND v(dout0_30) AT=495.025n

.meas tran vdout0_31ck980 FIND v(dout0_31) AT=495.025n

.meas tran vdout0_0ck990 FIND v(dout0_0) AT=500.025n

.meas tran vdout0_1ck990 FIND v(dout0_1) AT=500.025n

.meas tran vdout0_2ck990 FIND v(dout0_2) AT=500.025n

.meas tran vdout0_3ck990 FIND v(dout0_3) AT=500.025n

.meas tran vdout0_4ck990 FIND v(dout0_4) AT=500.025n

.meas tran vdout0_5ck990 FIND v(dout0_5) AT=500.025n

.meas tran vdout0_6ck990 FIND v(dout0_6) AT=500.025n

.meas tran vdout0_7ck990 FIND v(dout0_7) AT=500.025n

.meas tran vdout0_8ck990 FIND v(dout0_8) AT=500.025n

.meas tran vdout0_9ck990 FIND v(dout0_9) AT=500.025n

.meas tran vdout0_10ck990 FIND v(dout0_10) AT=500.025n

.meas tran vdout0_11ck990 FIND v(dout0_11) AT=500.025n

.meas tran vdout0_12ck990 FIND v(dout0_12) AT=500.025n

.meas tran vdout0_13ck990 FIND v(dout0_13) AT=500.025n

.meas tran vdout0_14ck990 FIND v(dout0_14) AT=500.025n

.meas tran vdout0_15ck990 FIND v(dout0_15) AT=500.025n

.meas tran vdout0_16ck990 FIND v(dout0_16) AT=500.025n

.meas tran vdout0_17ck990 FIND v(dout0_17) AT=500.025n

.meas tran vdout0_18ck990 FIND v(dout0_18) AT=500.025n

.meas tran vdout0_19ck990 FIND v(dout0_19) AT=500.025n

.meas tran vdout0_20ck990 FIND v(dout0_20) AT=500.025n

.meas tran vdout0_21ck990 FIND v(dout0_21) AT=500.025n

.meas tran vdout0_22ck990 FIND v(dout0_22) AT=500.025n

.meas tran vdout0_23ck990 FIND v(dout0_23) AT=500.025n

.meas tran vdout0_24ck990 FIND v(dout0_24) AT=500.025n

.meas tran vdout0_25ck990 FIND v(dout0_25) AT=500.025n

.meas tran vdout0_26ck990 FIND v(dout0_26) AT=500.025n

.meas tran vdout0_27ck990 FIND v(dout0_27) AT=500.025n

.meas tran vdout0_28ck990 FIND v(dout0_28) AT=500.025n

.meas tran vdout0_29ck990 FIND v(dout0_29) AT=500.025n

.meas tran vdout0_30ck990 FIND v(dout0_30) AT=500.025n

.meas tran vdout0_31ck990 FIND v(dout0_31) AT=500.025n

.meas tran vdout0_0ck1010 FIND v(dout0_0) AT=510.025n

.meas tran vdout0_1ck1010 FIND v(dout0_1) AT=510.025n

.meas tran vdout0_2ck1010 FIND v(dout0_2) AT=510.025n

.meas tran vdout0_3ck1010 FIND v(dout0_3) AT=510.025n

.meas tran vdout0_4ck1010 FIND v(dout0_4) AT=510.025n

.meas tran vdout0_5ck1010 FIND v(dout0_5) AT=510.025n

.meas tran vdout0_6ck1010 FIND v(dout0_6) AT=510.025n

.meas tran vdout0_7ck1010 FIND v(dout0_7) AT=510.025n

.meas tran vdout0_8ck1010 FIND v(dout0_8) AT=510.025n

.meas tran vdout0_9ck1010 FIND v(dout0_9) AT=510.025n

.meas tran vdout0_10ck1010 FIND v(dout0_10) AT=510.025n

.meas tran vdout0_11ck1010 FIND v(dout0_11) AT=510.025n

.meas tran vdout0_12ck1010 FIND v(dout0_12) AT=510.025n

.meas tran vdout0_13ck1010 FIND v(dout0_13) AT=510.025n

.meas tran vdout0_14ck1010 FIND v(dout0_14) AT=510.025n

.meas tran vdout0_15ck1010 FIND v(dout0_15) AT=510.025n

.meas tran vdout0_16ck1010 FIND v(dout0_16) AT=510.025n

.meas tran vdout0_17ck1010 FIND v(dout0_17) AT=510.025n

.meas tran vdout0_18ck1010 FIND v(dout0_18) AT=510.025n

.meas tran vdout0_19ck1010 FIND v(dout0_19) AT=510.025n

.meas tran vdout0_20ck1010 FIND v(dout0_20) AT=510.025n

.meas tran vdout0_21ck1010 FIND v(dout0_21) AT=510.025n

.meas tran vdout0_22ck1010 FIND v(dout0_22) AT=510.025n

.meas tran vdout0_23ck1010 FIND v(dout0_23) AT=510.025n

.meas tran vdout0_24ck1010 FIND v(dout0_24) AT=510.025n

.meas tran vdout0_25ck1010 FIND v(dout0_25) AT=510.025n

.meas tran vdout0_26ck1010 FIND v(dout0_26) AT=510.025n

.meas tran vdout0_27ck1010 FIND v(dout0_27) AT=510.025n

.meas tran vdout0_28ck1010 FIND v(dout0_28) AT=510.025n

.meas tran vdout0_29ck1010 FIND v(dout0_29) AT=510.025n

.meas tran vdout0_30ck1010 FIND v(dout0_30) AT=510.025n

.meas tran vdout0_31ck1010 FIND v(dout0_31) AT=510.025n

.meas tran vdout0_0ck1020 FIND v(dout0_0) AT=515.025n

.meas tran vdout0_1ck1020 FIND v(dout0_1) AT=515.025n

.meas tran vdout0_2ck1020 FIND v(dout0_2) AT=515.025n

.meas tran vdout0_3ck1020 FIND v(dout0_3) AT=515.025n

.meas tran vdout0_4ck1020 FIND v(dout0_4) AT=515.025n

.meas tran vdout0_5ck1020 FIND v(dout0_5) AT=515.025n

.meas tran vdout0_6ck1020 FIND v(dout0_6) AT=515.025n

.meas tran vdout0_7ck1020 FIND v(dout0_7) AT=515.025n

.meas tran vdout0_8ck1020 FIND v(dout0_8) AT=515.025n

.meas tran vdout0_9ck1020 FIND v(dout0_9) AT=515.025n

.meas tran vdout0_10ck1020 FIND v(dout0_10) AT=515.025n

.meas tran vdout0_11ck1020 FIND v(dout0_11) AT=515.025n

.meas tran vdout0_12ck1020 FIND v(dout0_12) AT=515.025n

.meas tran vdout0_13ck1020 FIND v(dout0_13) AT=515.025n

.meas tran vdout0_14ck1020 FIND v(dout0_14) AT=515.025n

.meas tran vdout0_15ck1020 FIND v(dout0_15) AT=515.025n

.meas tran vdout0_16ck1020 FIND v(dout0_16) AT=515.025n

.meas tran vdout0_17ck1020 FIND v(dout0_17) AT=515.025n

.meas tran vdout0_18ck1020 FIND v(dout0_18) AT=515.025n

.meas tran vdout0_19ck1020 FIND v(dout0_19) AT=515.025n

.meas tran vdout0_20ck1020 FIND v(dout0_20) AT=515.025n

.meas tran vdout0_21ck1020 FIND v(dout0_21) AT=515.025n

.meas tran vdout0_22ck1020 FIND v(dout0_22) AT=515.025n

.meas tran vdout0_23ck1020 FIND v(dout0_23) AT=515.025n

.meas tran vdout0_24ck1020 FIND v(dout0_24) AT=515.025n

.meas tran vdout0_25ck1020 FIND v(dout0_25) AT=515.025n

.meas tran vdout0_26ck1020 FIND v(dout0_26) AT=515.025n

.meas tran vdout0_27ck1020 FIND v(dout0_27) AT=515.025n

.meas tran vdout0_28ck1020 FIND v(dout0_28) AT=515.025n

.meas tran vdout0_29ck1020 FIND v(dout0_29) AT=515.025n

.meas tran vdout0_30ck1020 FIND v(dout0_30) AT=515.025n

.meas tran vdout0_31ck1020 FIND v(dout0_31) AT=515.025n

.meas tran vdout0_0ck1040 FIND v(dout0_0) AT=525.025n

.meas tran vdout0_1ck1040 FIND v(dout0_1) AT=525.025n

.meas tran vdout0_2ck1040 FIND v(dout0_2) AT=525.025n

.meas tran vdout0_3ck1040 FIND v(dout0_3) AT=525.025n

.meas tran vdout0_4ck1040 FIND v(dout0_4) AT=525.025n

.meas tran vdout0_5ck1040 FIND v(dout0_5) AT=525.025n

.meas tran vdout0_6ck1040 FIND v(dout0_6) AT=525.025n

.meas tran vdout0_7ck1040 FIND v(dout0_7) AT=525.025n

.meas tran vdout0_8ck1040 FIND v(dout0_8) AT=525.025n

.meas tran vdout0_9ck1040 FIND v(dout0_9) AT=525.025n

.meas tran vdout0_10ck1040 FIND v(dout0_10) AT=525.025n

.meas tran vdout0_11ck1040 FIND v(dout0_11) AT=525.025n

.meas tran vdout0_12ck1040 FIND v(dout0_12) AT=525.025n

.meas tran vdout0_13ck1040 FIND v(dout0_13) AT=525.025n

.meas tran vdout0_14ck1040 FIND v(dout0_14) AT=525.025n

.meas tran vdout0_15ck1040 FIND v(dout0_15) AT=525.025n

.meas tran vdout0_16ck1040 FIND v(dout0_16) AT=525.025n

.meas tran vdout0_17ck1040 FIND v(dout0_17) AT=525.025n

.meas tran vdout0_18ck1040 FIND v(dout0_18) AT=525.025n

.meas tran vdout0_19ck1040 FIND v(dout0_19) AT=525.025n

.meas tran vdout0_20ck1040 FIND v(dout0_20) AT=525.025n

.meas tran vdout0_21ck1040 FIND v(dout0_21) AT=525.025n

.meas tran vdout0_22ck1040 FIND v(dout0_22) AT=525.025n

.meas tran vdout0_23ck1040 FIND v(dout0_23) AT=525.025n

.meas tran vdout0_24ck1040 FIND v(dout0_24) AT=525.025n

.meas tran vdout0_25ck1040 FIND v(dout0_25) AT=525.025n

.meas tran vdout0_26ck1040 FIND v(dout0_26) AT=525.025n

.meas tran vdout0_27ck1040 FIND v(dout0_27) AT=525.025n

.meas tran vdout0_28ck1040 FIND v(dout0_28) AT=525.025n

.meas tran vdout0_29ck1040 FIND v(dout0_29) AT=525.025n

.meas tran vdout0_30ck1040 FIND v(dout0_30) AT=525.025n

.meas tran vdout0_31ck1040 FIND v(dout0_31) AT=525.025n

.meas tran vdout0_0ck1050 FIND v(dout0_0) AT=530.025n

.meas tran vdout0_1ck1050 FIND v(dout0_1) AT=530.025n

.meas tran vdout0_2ck1050 FIND v(dout0_2) AT=530.025n

.meas tran vdout0_3ck1050 FIND v(dout0_3) AT=530.025n

.meas tran vdout0_4ck1050 FIND v(dout0_4) AT=530.025n

.meas tran vdout0_5ck1050 FIND v(dout0_5) AT=530.025n

.meas tran vdout0_6ck1050 FIND v(dout0_6) AT=530.025n

.meas tran vdout0_7ck1050 FIND v(dout0_7) AT=530.025n

.meas tran vdout0_8ck1050 FIND v(dout0_8) AT=530.025n

.meas tran vdout0_9ck1050 FIND v(dout0_9) AT=530.025n

.meas tran vdout0_10ck1050 FIND v(dout0_10) AT=530.025n

.meas tran vdout0_11ck1050 FIND v(dout0_11) AT=530.025n

.meas tran vdout0_12ck1050 FIND v(dout0_12) AT=530.025n

.meas tran vdout0_13ck1050 FIND v(dout0_13) AT=530.025n

.meas tran vdout0_14ck1050 FIND v(dout0_14) AT=530.025n

.meas tran vdout0_15ck1050 FIND v(dout0_15) AT=530.025n

.meas tran vdout0_16ck1050 FIND v(dout0_16) AT=530.025n

.meas tran vdout0_17ck1050 FIND v(dout0_17) AT=530.025n

.meas tran vdout0_18ck1050 FIND v(dout0_18) AT=530.025n

.meas tran vdout0_19ck1050 FIND v(dout0_19) AT=530.025n

.meas tran vdout0_20ck1050 FIND v(dout0_20) AT=530.025n

.meas tran vdout0_21ck1050 FIND v(dout0_21) AT=530.025n

.meas tran vdout0_22ck1050 FIND v(dout0_22) AT=530.025n

.meas tran vdout0_23ck1050 FIND v(dout0_23) AT=530.025n

.meas tran vdout0_24ck1050 FIND v(dout0_24) AT=530.025n

.meas tran vdout0_25ck1050 FIND v(dout0_25) AT=530.025n

.meas tran vdout0_26ck1050 FIND v(dout0_26) AT=530.025n

.meas tran vdout0_27ck1050 FIND v(dout0_27) AT=530.025n

.meas tran vdout0_28ck1050 FIND v(dout0_28) AT=530.025n

.meas tran vdout0_29ck1050 FIND v(dout0_29) AT=530.025n

.meas tran vdout0_30ck1050 FIND v(dout0_30) AT=530.025n

.meas tran vdout0_31ck1050 FIND v(dout0_31) AT=530.025n

.meas tran vdout0_0ck1060 FIND v(dout0_0) AT=535.025n

.meas tran vdout0_1ck1060 FIND v(dout0_1) AT=535.025n

.meas tran vdout0_2ck1060 FIND v(dout0_2) AT=535.025n

.meas tran vdout0_3ck1060 FIND v(dout0_3) AT=535.025n

.meas tran vdout0_4ck1060 FIND v(dout0_4) AT=535.025n

.meas tran vdout0_5ck1060 FIND v(dout0_5) AT=535.025n

.meas tran vdout0_6ck1060 FIND v(dout0_6) AT=535.025n

.meas tran vdout0_7ck1060 FIND v(dout0_7) AT=535.025n

.meas tran vdout0_8ck1060 FIND v(dout0_8) AT=535.025n

.meas tran vdout0_9ck1060 FIND v(dout0_9) AT=535.025n

.meas tran vdout0_10ck1060 FIND v(dout0_10) AT=535.025n

.meas tran vdout0_11ck1060 FIND v(dout0_11) AT=535.025n

.meas tran vdout0_12ck1060 FIND v(dout0_12) AT=535.025n

.meas tran vdout0_13ck1060 FIND v(dout0_13) AT=535.025n

.meas tran vdout0_14ck1060 FIND v(dout0_14) AT=535.025n

.meas tran vdout0_15ck1060 FIND v(dout0_15) AT=535.025n

.meas tran vdout0_16ck1060 FIND v(dout0_16) AT=535.025n

.meas tran vdout0_17ck1060 FIND v(dout0_17) AT=535.025n

.meas tran vdout0_18ck1060 FIND v(dout0_18) AT=535.025n

.meas tran vdout0_19ck1060 FIND v(dout0_19) AT=535.025n

.meas tran vdout0_20ck1060 FIND v(dout0_20) AT=535.025n

.meas tran vdout0_21ck1060 FIND v(dout0_21) AT=535.025n

.meas tran vdout0_22ck1060 FIND v(dout0_22) AT=535.025n

.meas tran vdout0_23ck1060 FIND v(dout0_23) AT=535.025n

.meas tran vdout0_24ck1060 FIND v(dout0_24) AT=535.025n

.meas tran vdout0_25ck1060 FIND v(dout0_25) AT=535.025n

.meas tran vdout0_26ck1060 FIND v(dout0_26) AT=535.025n

.meas tran vdout0_27ck1060 FIND v(dout0_27) AT=535.025n

.meas tran vdout0_28ck1060 FIND v(dout0_28) AT=535.025n

.meas tran vdout0_29ck1060 FIND v(dout0_29) AT=535.025n

.meas tran vdout0_30ck1060 FIND v(dout0_30) AT=535.025n

.meas tran vdout0_31ck1060 FIND v(dout0_31) AT=535.025n

.meas tran vdout0_0ck1070 FIND v(dout0_0) AT=540.025n

.meas tran vdout0_1ck1070 FIND v(dout0_1) AT=540.025n

.meas tran vdout0_2ck1070 FIND v(dout0_2) AT=540.025n

.meas tran vdout0_3ck1070 FIND v(dout0_3) AT=540.025n

.meas tran vdout0_4ck1070 FIND v(dout0_4) AT=540.025n

.meas tran vdout0_5ck1070 FIND v(dout0_5) AT=540.025n

.meas tran vdout0_6ck1070 FIND v(dout0_6) AT=540.025n

.meas tran vdout0_7ck1070 FIND v(dout0_7) AT=540.025n

.meas tran vdout0_8ck1070 FIND v(dout0_8) AT=540.025n

.meas tran vdout0_9ck1070 FIND v(dout0_9) AT=540.025n

.meas tran vdout0_10ck1070 FIND v(dout0_10) AT=540.025n

.meas tran vdout0_11ck1070 FIND v(dout0_11) AT=540.025n

.meas tran vdout0_12ck1070 FIND v(dout0_12) AT=540.025n

.meas tran vdout0_13ck1070 FIND v(dout0_13) AT=540.025n

.meas tran vdout0_14ck1070 FIND v(dout0_14) AT=540.025n

.meas tran vdout0_15ck1070 FIND v(dout0_15) AT=540.025n

.meas tran vdout0_16ck1070 FIND v(dout0_16) AT=540.025n

.meas tran vdout0_17ck1070 FIND v(dout0_17) AT=540.025n

.meas tran vdout0_18ck1070 FIND v(dout0_18) AT=540.025n

.meas tran vdout0_19ck1070 FIND v(dout0_19) AT=540.025n

.meas tran vdout0_20ck1070 FIND v(dout0_20) AT=540.025n

.meas tran vdout0_21ck1070 FIND v(dout0_21) AT=540.025n

.meas tran vdout0_22ck1070 FIND v(dout0_22) AT=540.025n

.meas tran vdout0_23ck1070 FIND v(dout0_23) AT=540.025n

.meas tran vdout0_24ck1070 FIND v(dout0_24) AT=540.025n

.meas tran vdout0_25ck1070 FIND v(dout0_25) AT=540.025n

.meas tran vdout0_26ck1070 FIND v(dout0_26) AT=540.025n

.meas tran vdout0_27ck1070 FIND v(dout0_27) AT=540.025n

.meas tran vdout0_28ck1070 FIND v(dout0_28) AT=540.025n

.meas tran vdout0_29ck1070 FIND v(dout0_29) AT=540.025n

.meas tran vdout0_30ck1070 FIND v(dout0_30) AT=540.025n

.meas tran vdout0_31ck1070 FIND v(dout0_31) AT=540.025n

.meas tran vdout0_0ck1090 FIND v(dout0_0) AT=550.025n

.meas tran vdout0_1ck1090 FIND v(dout0_1) AT=550.025n

.meas tran vdout0_2ck1090 FIND v(dout0_2) AT=550.025n

.meas tran vdout0_3ck1090 FIND v(dout0_3) AT=550.025n

.meas tran vdout0_4ck1090 FIND v(dout0_4) AT=550.025n

.meas tran vdout0_5ck1090 FIND v(dout0_5) AT=550.025n

.meas tran vdout0_6ck1090 FIND v(dout0_6) AT=550.025n

.meas tran vdout0_7ck1090 FIND v(dout0_7) AT=550.025n

.meas tran vdout0_8ck1090 FIND v(dout0_8) AT=550.025n

.meas tran vdout0_9ck1090 FIND v(dout0_9) AT=550.025n

.meas tran vdout0_10ck1090 FIND v(dout0_10) AT=550.025n

.meas tran vdout0_11ck1090 FIND v(dout0_11) AT=550.025n

.meas tran vdout0_12ck1090 FIND v(dout0_12) AT=550.025n

.meas tran vdout0_13ck1090 FIND v(dout0_13) AT=550.025n

.meas tran vdout0_14ck1090 FIND v(dout0_14) AT=550.025n

.meas tran vdout0_15ck1090 FIND v(dout0_15) AT=550.025n

.meas tran vdout0_16ck1090 FIND v(dout0_16) AT=550.025n

.meas tran vdout0_17ck1090 FIND v(dout0_17) AT=550.025n

.meas tran vdout0_18ck1090 FIND v(dout0_18) AT=550.025n

.meas tran vdout0_19ck1090 FIND v(dout0_19) AT=550.025n

.meas tran vdout0_20ck1090 FIND v(dout0_20) AT=550.025n

.meas tran vdout0_21ck1090 FIND v(dout0_21) AT=550.025n

.meas tran vdout0_22ck1090 FIND v(dout0_22) AT=550.025n

.meas tran vdout0_23ck1090 FIND v(dout0_23) AT=550.025n

.meas tran vdout0_24ck1090 FIND v(dout0_24) AT=550.025n

.meas tran vdout0_25ck1090 FIND v(dout0_25) AT=550.025n

.meas tran vdout0_26ck1090 FIND v(dout0_26) AT=550.025n

.meas tran vdout0_27ck1090 FIND v(dout0_27) AT=550.025n

.meas tran vdout0_28ck1090 FIND v(dout0_28) AT=550.025n

.meas tran vdout0_29ck1090 FIND v(dout0_29) AT=550.025n

.meas tran vdout0_30ck1090 FIND v(dout0_30) AT=550.025n

.meas tran vdout0_31ck1090 FIND v(dout0_31) AT=550.025n

.meas tran vdout0_0ck1100 FIND v(dout0_0) AT=555.025n

.meas tran vdout0_1ck1100 FIND v(dout0_1) AT=555.025n

.meas tran vdout0_2ck1100 FIND v(dout0_2) AT=555.025n

.meas tran vdout0_3ck1100 FIND v(dout0_3) AT=555.025n

.meas tran vdout0_4ck1100 FIND v(dout0_4) AT=555.025n

.meas tran vdout0_5ck1100 FIND v(dout0_5) AT=555.025n

.meas tran vdout0_6ck1100 FIND v(dout0_6) AT=555.025n

.meas tran vdout0_7ck1100 FIND v(dout0_7) AT=555.025n

.meas tran vdout0_8ck1100 FIND v(dout0_8) AT=555.025n

.meas tran vdout0_9ck1100 FIND v(dout0_9) AT=555.025n

.meas tran vdout0_10ck1100 FIND v(dout0_10) AT=555.025n

.meas tran vdout0_11ck1100 FIND v(dout0_11) AT=555.025n

.meas tran vdout0_12ck1100 FIND v(dout0_12) AT=555.025n

.meas tran vdout0_13ck1100 FIND v(dout0_13) AT=555.025n

.meas tran vdout0_14ck1100 FIND v(dout0_14) AT=555.025n

.meas tran vdout0_15ck1100 FIND v(dout0_15) AT=555.025n

.meas tran vdout0_16ck1100 FIND v(dout0_16) AT=555.025n

.meas tran vdout0_17ck1100 FIND v(dout0_17) AT=555.025n

.meas tran vdout0_18ck1100 FIND v(dout0_18) AT=555.025n

.meas tran vdout0_19ck1100 FIND v(dout0_19) AT=555.025n

.meas tran vdout0_20ck1100 FIND v(dout0_20) AT=555.025n

.meas tran vdout0_21ck1100 FIND v(dout0_21) AT=555.025n

.meas tran vdout0_22ck1100 FIND v(dout0_22) AT=555.025n

.meas tran vdout0_23ck1100 FIND v(dout0_23) AT=555.025n

.meas tran vdout0_24ck1100 FIND v(dout0_24) AT=555.025n

.meas tran vdout0_25ck1100 FIND v(dout0_25) AT=555.025n

.meas tran vdout0_26ck1100 FIND v(dout0_26) AT=555.025n

.meas tran vdout0_27ck1100 FIND v(dout0_27) AT=555.025n

.meas tran vdout0_28ck1100 FIND v(dout0_28) AT=555.025n

.meas tran vdout0_29ck1100 FIND v(dout0_29) AT=555.025n

.meas tran vdout0_30ck1100 FIND v(dout0_30) AT=555.025n

.meas tran vdout0_31ck1100 FIND v(dout0_31) AT=555.025n

.meas tran vdout0_0ck1120 FIND v(dout0_0) AT=565.025n

.meas tran vdout0_1ck1120 FIND v(dout0_1) AT=565.025n

.meas tran vdout0_2ck1120 FIND v(dout0_2) AT=565.025n

.meas tran vdout0_3ck1120 FIND v(dout0_3) AT=565.025n

.meas tran vdout0_4ck1120 FIND v(dout0_4) AT=565.025n

.meas tran vdout0_5ck1120 FIND v(dout0_5) AT=565.025n

.meas tran vdout0_6ck1120 FIND v(dout0_6) AT=565.025n

.meas tran vdout0_7ck1120 FIND v(dout0_7) AT=565.025n

.meas tran vdout0_8ck1120 FIND v(dout0_8) AT=565.025n

.meas tran vdout0_9ck1120 FIND v(dout0_9) AT=565.025n

.meas tran vdout0_10ck1120 FIND v(dout0_10) AT=565.025n

.meas tran vdout0_11ck1120 FIND v(dout0_11) AT=565.025n

.meas tran vdout0_12ck1120 FIND v(dout0_12) AT=565.025n

.meas tran vdout0_13ck1120 FIND v(dout0_13) AT=565.025n

.meas tran vdout0_14ck1120 FIND v(dout0_14) AT=565.025n

.meas tran vdout0_15ck1120 FIND v(dout0_15) AT=565.025n

.meas tran vdout0_16ck1120 FIND v(dout0_16) AT=565.025n

.meas tran vdout0_17ck1120 FIND v(dout0_17) AT=565.025n

.meas tran vdout0_18ck1120 FIND v(dout0_18) AT=565.025n

.meas tran vdout0_19ck1120 FIND v(dout0_19) AT=565.025n

.meas tran vdout0_20ck1120 FIND v(dout0_20) AT=565.025n

.meas tran vdout0_21ck1120 FIND v(dout0_21) AT=565.025n

.meas tran vdout0_22ck1120 FIND v(dout0_22) AT=565.025n

.meas tran vdout0_23ck1120 FIND v(dout0_23) AT=565.025n

.meas tran vdout0_24ck1120 FIND v(dout0_24) AT=565.025n

.meas tran vdout0_25ck1120 FIND v(dout0_25) AT=565.025n

.meas tran vdout0_26ck1120 FIND v(dout0_26) AT=565.025n

.meas tran vdout0_27ck1120 FIND v(dout0_27) AT=565.025n

.meas tran vdout0_28ck1120 FIND v(dout0_28) AT=565.025n

.meas tran vdout0_29ck1120 FIND v(dout0_29) AT=565.025n

.meas tran vdout0_30ck1120 FIND v(dout0_30) AT=565.025n

.meas tran vdout0_31ck1120 FIND v(dout0_31) AT=565.025n

.meas tran vdout0_0ck1130 FIND v(dout0_0) AT=570.025n

.meas tran vdout0_1ck1130 FIND v(dout0_1) AT=570.025n

.meas tran vdout0_2ck1130 FIND v(dout0_2) AT=570.025n

.meas tran vdout0_3ck1130 FIND v(dout0_3) AT=570.025n

.meas tran vdout0_4ck1130 FIND v(dout0_4) AT=570.025n

.meas tran vdout0_5ck1130 FIND v(dout0_5) AT=570.025n

.meas tran vdout0_6ck1130 FIND v(dout0_6) AT=570.025n

.meas tran vdout0_7ck1130 FIND v(dout0_7) AT=570.025n

.meas tran vdout0_8ck1130 FIND v(dout0_8) AT=570.025n

.meas tran vdout0_9ck1130 FIND v(dout0_9) AT=570.025n

.meas tran vdout0_10ck1130 FIND v(dout0_10) AT=570.025n

.meas tran vdout0_11ck1130 FIND v(dout0_11) AT=570.025n

.meas tran vdout0_12ck1130 FIND v(dout0_12) AT=570.025n

.meas tran vdout0_13ck1130 FIND v(dout0_13) AT=570.025n

.meas tran vdout0_14ck1130 FIND v(dout0_14) AT=570.025n

.meas tran vdout0_15ck1130 FIND v(dout0_15) AT=570.025n

.meas tran vdout0_16ck1130 FIND v(dout0_16) AT=570.025n

.meas tran vdout0_17ck1130 FIND v(dout0_17) AT=570.025n

.meas tran vdout0_18ck1130 FIND v(dout0_18) AT=570.025n

.meas tran vdout0_19ck1130 FIND v(dout0_19) AT=570.025n

.meas tran vdout0_20ck1130 FIND v(dout0_20) AT=570.025n

.meas tran vdout0_21ck1130 FIND v(dout0_21) AT=570.025n

.meas tran vdout0_22ck1130 FIND v(dout0_22) AT=570.025n

.meas tran vdout0_23ck1130 FIND v(dout0_23) AT=570.025n

.meas tran vdout0_24ck1130 FIND v(dout0_24) AT=570.025n

.meas tran vdout0_25ck1130 FIND v(dout0_25) AT=570.025n

.meas tran vdout0_26ck1130 FIND v(dout0_26) AT=570.025n

.meas tran vdout0_27ck1130 FIND v(dout0_27) AT=570.025n

.meas tran vdout0_28ck1130 FIND v(dout0_28) AT=570.025n

.meas tran vdout0_29ck1130 FIND v(dout0_29) AT=570.025n

.meas tran vdout0_30ck1130 FIND v(dout0_30) AT=570.025n

.meas tran vdout0_31ck1130 FIND v(dout0_31) AT=570.025n

.meas tran vdout0_0ck1140 FIND v(dout0_0) AT=575.025n

.meas tran vdout0_1ck1140 FIND v(dout0_1) AT=575.025n

.meas tran vdout0_2ck1140 FIND v(dout0_2) AT=575.025n

.meas tran vdout0_3ck1140 FIND v(dout0_3) AT=575.025n

.meas tran vdout0_4ck1140 FIND v(dout0_4) AT=575.025n

.meas tran vdout0_5ck1140 FIND v(dout0_5) AT=575.025n

.meas tran vdout0_6ck1140 FIND v(dout0_6) AT=575.025n

.meas tran vdout0_7ck1140 FIND v(dout0_7) AT=575.025n

.meas tran vdout0_8ck1140 FIND v(dout0_8) AT=575.025n

.meas tran vdout0_9ck1140 FIND v(dout0_9) AT=575.025n

.meas tran vdout0_10ck1140 FIND v(dout0_10) AT=575.025n

.meas tran vdout0_11ck1140 FIND v(dout0_11) AT=575.025n

.meas tran vdout0_12ck1140 FIND v(dout0_12) AT=575.025n

.meas tran vdout0_13ck1140 FIND v(dout0_13) AT=575.025n

.meas tran vdout0_14ck1140 FIND v(dout0_14) AT=575.025n

.meas tran vdout0_15ck1140 FIND v(dout0_15) AT=575.025n

.meas tran vdout0_16ck1140 FIND v(dout0_16) AT=575.025n

.meas tran vdout0_17ck1140 FIND v(dout0_17) AT=575.025n

.meas tran vdout0_18ck1140 FIND v(dout0_18) AT=575.025n

.meas tran vdout0_19ck1140 FIND v(dout0_19) AT=575.025n

.meas tran vdout0_20ck1140 FIND v(dout0_20) AT=575.025n

.meas tran vdout0_21ck1140 FIND v(dout0_21) AT=575.025n

.meas tran vdout0_22ck1140 FIND v(dout0_22) AT=575.025n

.meas tran vdout0_23ck1140 FIND v(dout0_23) AT=575.025n

.meas tran vdout0_24ck1140 FIND v(dout0_24) AT=575.025n

.meas tran vdout0_25ck1140 FIND v(dout0_25) AT=575.025n

.meas tran vdout0_26ck1140 FIND v(dout0_26) AT=575.025n

.meas tran vdout0_27ck1140 FIND v(dout0_27) AT=575.025n

.meas tran vdout0_28ck1140 FIND v(dout0_28) AT=575.025n

.meas tran vdout0_29ck1140 FIND v(dout0_29) AT=575.025n

.meas tran vdout0_30ck1140 FIND v(dout0_30) AT=575.025n

.meas tran vdout0_31ck1140 FIND v(dout0_31) AT=575.025n

.meas tran vdout0_0ck1150 FIND v(dout0_0) AT=580.025n

.meas tran vdout0_1ck1150 FIND v(dout0_1) AT=580.025n

.meas tran vdout0_2ck1150 FIND v(dout0_2) AT=580.025n

.meas tran vdout0_3ck1150 FIND v(dout0_3) AT=580.025n

.meas tran vdout0_4ck1150 FIND v(dout0_4) AT=580.025n

.meas tran vdout0_5ck1150 FIND v(dout0_5) AT=580.025n

.meas tran vdout0_6ck1150 FIND v(dout0_6) AT=580.025n

.meas tran vdout0_7ck1150 FIND v(dout0_7) AT=580.025n

.meas tran vdout0_8ck1150 FIND v(dout0_8) AT=580.025n

.meas tran vdout0_9ck1150 FIND v(dout0_9) AT=580.025n

.meas tran vdout0_10ck1150 FIND v(dout0_10) AT=580.025n

.meas tran vdout0_11ck1150 FIND v(dout0_11) AT=580.025n

.meas tran vdout0_12ck1150 FIND v(dout0_12) AT=580.025n

.meas tran vdout0_13ck1150 FIND v(dout0_13) AT=580.025n

.meas tran vdout0_14ck1150 FIND v(dout0_14) AT=580.025n

.meas tran vdout0_15ck1150 FIND v(dout0_15) AT=580.025n

.meas tran vdout0_16ck1150 FIND v(dout0_16) AT=580.025n

.meas tran vdout0_17ck1150 FIND v(dout0_17) AT=580.025n

.meas tran vdout0_18ck1150 FIND v(dout0_18) AT=580.025n

.meas tran vdout0_19ck1150 FIND v(dout0_19) AT=580.025n

.meas tran vdout0_20ck1150 FIND v(dout0_20) AT=580.025n

.meas tran vdout0_21ck1150 FIND v(dout0_21) AT=580.025n

.meas tran vdout0_22ck1150 FIND v(dout0_22) AT=580.025n

.meas tran vdout0_23ck1150 FIND v(dout0_23) AT=580.025n

.meas tran vdout0_24ck1150 FIND v(dout0_24) AT=580.025n

.meas tran vdout0_25ck1150 FIND v(dout0_25) AT=580.025n

.meas tran vdout0_26ck1150 FIND v(dout0_26) AT=580.025n

.meas tran vdout0_27ck1150 FIND v(dout0_27) AT=580.025n

.meas tran vdout0_28ck1150 FIND v(dout0_28) AT=580.025n

.meas tran vdout0_29ck1150 FIND v(dout0_29) AT=580.025n

.meas tran vdout0_30ck1150 FIND v(dout0_30) AT=580.025n

.meas tran vdout0_31ck1150 FIND v(dout0_31) AT=580.025n

.meas tran vdout0_0ck1180 FIND v(dout0_0) AT=595.025n

.meas tran vdout0_1ck1180 FIND v(dout0_1) AT=595.025n

.meas tran vdout0_2ck1180 FIND v(dout0_2) AT=595.025n

.meas tran vdout0_3ck1180 FIND v(dout0_3) AT=595.025n

.meas tran vdout0_4ck1180 FIND v(dout0_4) AT=595.025n

.meas tran vdout0_5ck1180 FIND v(dout0_5) AT=595.025n

.meas tran vdout0_6ck1180 FIND v(dout0_6) AT=595.025n

.meas tran vdout0_7ck1180 FIND v(dout0_7) AT=595.025n

.meas tran vdout0_8ck1180 FIND v(dout0_8) AT=595.025n

.meas tran vdout0_9ck1180 FIND v(dout0_9) AT=595.025n

.meas tran vdout0_10ck1180 FIND v(dout0_10) AT=595.025n

.meas tran vdout0_11ck1180 FIND v(dout0_11) AT=595.025n

.meas tran vdout0_12ck1180 FIND v(dout0_12) AT=595.025n

.meas tran vdout0_13ck1180 FIND v(dout0_13) AT=595.025n

.meas tran vdout0_14ck1180 FIND v(dout0_14) AT=595.025n

.meas tran vdout0_15ck1180 FIND v(dout0_15) AT=595.025n

.meas tran vdout0_16ck1180 FIND v(dout0_16) AT=595.025n

.meas tran vdout0_17ck1180 FIND v(dout0_17) AT=595.025n

.meas tran vdout0_18ck1180 FIND v(dout0_18) AT=595.025n

.meas tran vdout0_19ck1180 FIND v(dout0_19) AT=595.025n

.meas tran vdout0_20ck1180 FIND v(dout0_20) AT=595.025n

.meas tran vdout0_21ck1180 FIND v(dout0_21) AT=595.025n

.meas tran vdout0_22ck1180 FIND v(dout0_22) AT=595.025n

.meas tran vdout0_23ck1180 FIND v(dout0_23) AT=595.025n

.meas tran vdout0_24ck1180 FIND v(dout0_24) AT=595.025n

.meas tran vdout0_25ck1180 FIND v(dout0_25) AT=595.025n

.meas tran vdout0_26ck1180 FIND v(dout0_26) AT=595.025n

.meas tran vdout0_27ck1180 FIND v(dout0_27) AT=595.025n

.meas tran vdout0_28ck1180 FIND v(dout0_28) AT=595.025n

.meas tran vdout0_29ck1180 FIND v(dout0_29) AT=595.025n

.meas tran vdout0_30ck1180 FIND v(dout0_30) AT=595.025n

.meas tran vdout0_31ck1180 FIND v(dout0_31) AT=595.025n

.meas tran vdout0_0ck1190 FIND v(dout0_0) AT=600.025n

.meas tran vdout0_1ck1190 FIND v(dout0_1) AT=600.025n

.meas tran vdout0_2ck1190 FIND v(dout0_2) AT=600.025n

.meas tran vdout0_3ck1190 FIND v(dout0_3) AT=600.025n

.meas tran vdout0_4ck1190 FIND v(dout0_4) AT=600.025n

.meas tran vdout0_5ck1190 FIND v(dout0_5) AT=600.025n

.meas tran vdout0_6ck1190 FIND v(dout0_6) AT=600.025n

.meas tran vdout0_7ck1190 FIND v(dout0_7) AT=600.025n

.meas tran vdout0_8ck1190 FIND v(dout0_8) AT=600.025n

.meas tran vdout0_9ck1190 FIND v(dout0_9) AT=600.025n

.meas tran vdout0_10ck1190 FIND v(dout0_10) AT=600.025n

.meas tran vdout0_11ck1190 FIND v(dout0_11) AT=600.025n

.meas tran vdout0_12ck1190 FIND v(dout0_12) AT=600.025n

.meas tran vdout0_13ck1190 FIND v(dout0_13) AT=600.025n

.meas tran vdout0_14ck1190 FIND v(dout0_14) AT=600.025n

.meas tran vdout0_15ck1190 FIND v(dout0_15) AT=600.025n

.meas tran vdout0_16ck1190 FIND v(dout0_16) AT=600.025n

.meas tran vdout0_17ck1190 FIND v(dout0_17) AT=600.025n

.meas tran vdout0_18ck1190 FIND v(dout0_18) AT=600.025n

.meas tran vdout0_19ck1190 FIND v(dout0_19) AT=600.025n

.meas tran vdout0_20ck1190 FIND v(dout0_20) AT=600.025n

.meas tran vdout0_21ck1190 FIND v(dout0_21) AT=600.025n

.meas tran vdout0_22ck1190 FIND v(dout0_22) AT=600.025n

.meas tran vdout0_23ck1190 FIND v(dout0_23) AT=600.025n

.meas tran vdout0_24ck1190 FIND v(dout0_24) AT=600.025n

.meas tran vdout0_25ck1190 FIND v(dout0_25) AT=600.025n

.meas tran vdout0_26ck1190 FIND v(dout0_26) AT=600.025n

.meas tran vdout0_27ck1190 FIND v(dout0_27) AT=600.025n

.meas tran vdout0_28ck1190 FIND v(dout0_28) AT=600.025n

.meas tran vdout0_29ck1190 FIND v(dout0_29) AT=600.025n

.meas tran vdout0_30ck1190 FIND v(dout0_30) AT=600.025n

.meas tran vdout0_31ck1190 FIND v(dout0_31) AT=600.025n

.meas tran vdout0_0ck1210 FIND v(dout0_0) AT=610.025n

.meas tran vdout0_1ck1210 FIND v(dout0_1) AT=610.025n

.meas tran vdout0_2ck1210 FIND v(dout0_2) AT=610.025n

.meas tran vdout0_3ck1210 FIND v(dout0_3) AT=610.025n

.meas tran vdout0_4ck1210 FIND v(dout0_4) AT=610.025n

.meas tran vdout0_5ck1210 FIND v(dout0_5) AT=610.025n

.meas tran vdout0_6ck1210 FIND v(dout0_6) AT=610.025n

.meas tran vdout0_7ck1210 FIND v(dout0_7) AT=610.025n

.meas tran vdout0_8ck1210 FIND v(dout0_8) AT=610.025n

.meas tran vdout0_9ck1210 FIND v(dout0_9) AT=610.025n

.meas tran vdout0_10ck1210 FIND v(dout0_10) AT=610.025n

.meas tran vdout0_11ck1210 FIND v(dout0_11) AT=610.025n

.meas tran vdout0_12ck1210 FIND v(dout0_12) AT=610.025n

.meas tran vdout0_13ck1210 FIND v(dout0_13) AT=610.025n

.meas tran vdout0_14ck1210 FIND v(dout0_14) AT=610.025n

.meas tran vdout0_15ck1210 FIND v(dout0_15) AT=610.025n

.meas tran vdout0_16ck1210 FIND v(dout0_16) AT=610.025n

.meas tran vdout0_17ck1210 FIND v(dout0_17) AT=610.025n

.meas tran vdout0_18ck1210 FIND v(dout0_18) AT=610.025n

.meas tran vdout0_19ck1210 FIND v(dout0_19) AT=610.025n

.meas tran vdout0_20ck1210 FIND v(dout0_20) AT=610.025n

.meas tran vdout0_21ck1210 FIND v(dout0_21) AT=610.025n

.meas tran vdout0_22ck1210 FIND v(dout0_22) AT=610.025n

.meas tran vdout0_23ck1210 FIND v(dout0_23) AT=610.025n

.meas tran vdout0_24ck1210 FIND v(dout0_24) AT=610.025n

.meas tran vdout0_25ck1210 FIND v(dout0_25) AT=610.025n

.meas tran vdout0_26ck1210 FIND v(dout0_26) AT=610.025n

.meas tran vdout0_27ck1210 FIND v(dout0_27) AT=610.025n

.meas tran vdout0_28ck1210 FIND v(dout0_28) AT=610.025n

.meas tran vdout0_29ck1210 FIND v(dout0_29) AT=610.025n

.meas tran vdout0_30ck1210 FIND v(dout0_30) AT=610.025n

.meas tran vdout0_31ck1210 FIND v(dout0_31) AT=610.025n

.meas tran vdout0_0ck1230 FIND v(dout0_0) AT=620.025n

.meas tran vdout0_1ck1230 FIND v(dout0_1) AT=620.025n

.meas tran vdout0_2ck1230 FIND v(dout0_2) AT=620.025n

.meas tran vdout0_3ck1230 FIND v(dout0_3) AT=620.025n

.meas tran vdout0_4ck1230 FIND v(dout0_4) AT=620.025n

.meas tran vdout0_5ck1230 FIND v(dout0_5) AT=620.025n

.meas tran vdout0_6ck1230 FIND v(dout0_6) AT=620.025n

.meas tran vdout0_7ck1230 FIND v(dout0_7) AT=620.025n

.meas tran vdout0_8ck1230 FIND v(dout0_8) AT=620.025n

.meas tran vdout0_9ck1230 FIND v(dout0_9) AT=620.025n

.meas tran vdout0_10ck1230 FIND v(dout0_10) AT=620.025n

.meas tran vdout0_11ck1230 FIND v(dout0_11) AT=620.025n

.meas tran vdout0_12ck1230 FIND v(dout0_12) AT=620.025n

.meas tran vdout0_13ck1230 FIND v(dout0_13) AT=620.025n

.meas tran vdout0_14ck1230 FIND v(dout0_14) AT=620.025n

.meas tran vdout0_15ck1230 FIND v(dout0_15) AT=620.025n

.meas tran vdout0_16ck1230 FIND v(dout0_16) AT=620.025n

.meas tran vdout0_17ck1230 FIND v(dout0_17) AT=620.025n

.meas tran vdout0_18ck1230 FIND v(dout0_18) AT=620.025n

.meas tran vdout0_19ck1230 FIND v(dout0_19) AT=620.025n

.meas tran vdout0_20ck1230 FIND v(dout0_20) AT=620.025n

.meas tran vdout0_21ck1230 FIND v(dout0_21) AT=620.025n

.meas tran vdout0_22ck1230 FIND v(dout0_22) AT=620.025n

.meas tran vdout0_23ck1230 FIND v(dout0_23) AT=620.025n

.meas tran vdout0_24ck1230 FIND v(dout0_24) AT=620.025n

.meas tran vdout0_25ck1230 FIND v(dout0_25) AT=620.025n

.meas tran vdout0_26ck1230 FIND v(dout0_26) AT=620.025n

.meas tran vdout0_27ck1230 FIND v(dout0_27) AT=620.025n

.meas tran vdout0_28ck1230 FIND v(dout0_28) AT=620.025n

.meas tran vdout0_29ck1230 FIND v(dout0_29) AT=620.025n

.meas tran vdout0_30ck1230 FIND v(dout0_30) AT=620.025n

.meas tran vdout0_31ck1230 FIND v(dout0_31) AT=620.025n

.meas tran vdout0_0ck1240 FIND v(dout0_0) AT=625.025n

.meas tran vdout0_1ck1240 FIND v(dout0_1) AT=625.025n

.meas tran vdout0_2ck1240 FIND v(dout0_2) AT=625.025n

.meas tran vdout0_3ck1240 FIND v(dout0_3) AT=625.025n

.meas tran vdout0_4ck1240 FIND v(dout0_4) AT=625.025n

.meas tran vdout0_5ck1240 FIND v(dout0_5) AT=625.025n

.meas tran vdout0_6ck1240 FIND v(dout0_6) AT=625.025n

.meas tran vdout0_7ck1240 FIND v(dout0_7) AT=625.025n

.meas tran vdout0_8ck1240 FIND v(dout0_8) AT=625.025n

.meas tran vdout0_9ck1240 FIND v(dout0_9) AT=625.025n

.meas tran vdout0_10ck1240 FIND v(dout0_10) AT=625.025n

.meas tran vdout0_11ck1240 FIND v(dout0_11) AT=625.025n

.meas tran vdout0_12ck1240 FIND v(dout0_12) AT=625.025n

.meas tran vdout0_13ck1240 FIND v(dout0_13) AT=625.025n

.meas tran vdout0_14ck1240 FIND v(dout0_14) AT=625.025n

.meas tran vdout0_15ck1240 FIND v(dout0_15) AT=625.025n

.meas tran vdout0_16ck1240 FIND v(dout0_16) AT=625.025n

.meas tran vdout0_17ck1240 FIND v(dout0_17) AT=625.025n

.meas tran vdout0_18ck1240 FIND v(dout0_18) AT=625.025n

.meas tran vdout0_19ck1240 FIND v(dout0_19) AT=625.025n

.meas tran vdout0_20ck1240 FIND v(dout0_20) AT=625.025n

.meas tran vdout0_21ck1240 FIND v(dout0_21) AT=625.025n

.meas tran vdout0_22ck1240 FIND v(dout0_22) AT=625.025n

.meas tran vdout0_23ck1240 FIND v(dout0_23) AT=625.025n

.meas tran vdout0_24ck1240 FIND v(dout0_24) AT=625.025n

.meas tran vdout0_25ck1240 FIND v(dout0_25) AT=625.025n

.meas tran vdout0_26ck1240 FIND v(dout0_26) AT=625.025n

.meas tran vdout0_27ck1240 FIND v(dout0_27) AT=625.025n

.meas tran vdout0_28ck1240 FIND v(dout0_28) AT=625.025n

.meas tran vdout0_29ck1240 FIND v(dout0_29) AT=625.025n

.meas tran vdout0_30ck1240 FIND v(dout0_30) AT=625.025n

.meas tran vdout0_31ck1240 FIND v(dout0_31) AT=625.025n

.meas tran vdout0_0ck1260 FIND v(dout0_0) AT=635.025n

.meas tran vdout0_1ck1260 FIND v(dout0_1) AT=635.025n

.meas tran vdout0_2ck1260 FIND v(dout0_2) AT=635.025n

.meas tran vdout0_3ck1260 FIND v(dout0_3) AT=635.025n

.meas tran vdout0_4ck1260 FIND v(dout0_4) AT=635.025n

.meas tran vdout0_5ck1260 FIND v(dout0_5) AT=635.025n

.meas tran vdout0_6ck1260 FIND v(dout0_6) AT=635.025n

.meas tran vdout0_7ck1260 FIND v(dout0_7) AT=635.025n

.meas tran vdout0_8ck1260 FIND v(dout0_8) AT=635.025n

.meas tran vdout0_9ck1260 FIND v(dout0_9) AT=635.025n

.meas tran vdout0_10ck1260 FIND v(dout0_10) AT=635.025n

.meas tran vdout0_11ck1260 FIND v(dout0_11) AT=635.025n

.meas tran vdout0_12ck1260 FIND v(dout0_12) AT=635.025n

.meas tran vdout0_13ck1260 FIND v(dout0_13) AT=635.025n

.meas tran vdout0_14ck1260 FIND v(dout0_14) AT=635.025n

.meas tran vdout0_15ck1260 FIND v(dout0_15) AT=635.025n

.meas tran vdout0_16ck1260 FIND v(dout0_16) AT=635.025n

.meas tran vdout0_17ck1260 FIND v(dout0_17) AT=635.025n

.meas tran vdout0_18ck1260 FIND v(dout0_18) AT=635.025n

.meas tran vdout0_19ck1260 FIND v(dout0_19) AT=635.025n

.meas tran vdout0_20ck1260 FIND v(dout0_20) AT=635.025n

.meas tran vdout0_21ck1260 FIND v(dout0_21) AT=635.025n

.meas tran vdout0_22ck1260 FIND v(dout0_22) AT=635.025n

.meas tran vdout0_23ck1260 FIND v(dout0_23) AT=635.025n

.meas tran vdout0_24ck1260 FIND v(dout0_24) AT=635.025n

.meas tran vdout0_25ck1260 FIND v(dout0_25) AT=635.025n

.meas tran vdout0_26ck1260 FIND v(dout0_26) AT=635.025n

.meas tran vdout0_27ck1260 FIND v(dout0_27) AT=635.025n

.meas tran vdout0_28ck1260 FIND v(dout0_28) AT=635.025n

.meas tran vdout0_29ck1260 FIND v(dout0_29) AT=635.025n

.meas tran vdout0_30ck1260 FIND v(dout0_30) AT=635.025n

.meas tran vdout0_31ck1260 FIND v(dout0_31) AT=635.025n

.meas tran vdout0_0ck1270 FIND v(dout0_0) AT=640.025n

.meas tran vdout0_1ck1270 FIND v(dout0_1) AT=640.025n

.meas tran vdout0_2ck1270 FIND v(dout0_2) AT=640.025n

.meas tran vdout0_3ck1270 FIND v(dout0_3) AT=640.025n

.meas tran vdout0_4ck1270 FIND v(dout0_4) AT=640.025n

.meas tran vdout0_5ck1270 FIND v(dout0_5) AT=640.025n

.meas tran vdout0_6ck1270 FIND v(dout0_6) AT=640.025n

.meas tran vdout0_7ck1270 FIND v(dout0_7) AT=640.025n

.meas tran vdout0_8ck1270 FIND v(dout0_8) AT=640.025n

.meas tran vdout0_9ck1270 FIND v(dout0_9) AT=640.025n

.meas tran vdout0_10ck1270 FIND v(dout0_10) AT=640.025n

.meas tran vdout0_11ck1270 FIND v(dout0_11) AT=640.025n

.meas tran vdout0_12ck1270 FIND v(dout0_12) AT=640.025n

.meas tran vdout0_13ck1270 FIND v(dout0_13) AT=640.025n

.meas tran vdout0_14ck1270 FIND v(dout0_14) AT=640.025n

.meas tran vdout0_15ck1270 FIND v(dout0_15) AT=640.025n

.meas tran vdout0_16ck1270 FIND v(dout0_16) AT=640.025n

.meas tran vdout0_17ck1270 FIND v(dout0_17) AT=640.025n

.meas tran vdout0_18ck1270 FIND v(dout0_18) AT=640.025n

.meas tran vdout0_19ck1270 FIND v(dout0_19) AT=640.025n

.meas tran vdout0_20ck1270 FIND v(dout0_20) AT=640.025n

.meas tran vdout0_21ck1270 FIND v(dout0_21) AT=640.025n

.meas tran vdout0_22ck1270 FIND v(dout0_22) AT=640.025n

.meas tran vdout0_23ck1270 FIND v(dout0_23) AT=640.025n

.meas tran vdout0_24ck1270 FIND v(dout0_24) AT=640.025n

.meas tran vdout0_25ck1270 FIND v(dout0_25) AT=640.025n

.meas tran vdout0_26ck1270 FIND v(dout0_26) AT=640.025n

.meas tran vdout0_27ck1270 FIND v(dout0_27) AT=640.025n

.meas tran vdout0_28ck1270 FIND v(dout0_28) AT=640.025n

.meas tran vdout0_29ck1270 FIND v(dout0_29) AT=640.025n

.meas tran vdout0_30ck1270 FIND v(dout0_30) AT=640.025n

.meas tran vdout0_31ck1270 FIND v(dout0_31) AT=640.025n

.meas tran vdout0_0ck1280 FIND v(dout0_0) AT=645.025n

.meas tran vdout0_1ck1280 FIND v(dout0_1) AT=645.025n

.meas tran vdout0_2ck1280 FIND v(dout0_2) AT=645.025n

.meas tran vdout0_3ck1280 FIND v(dout0_3) AT=645.025n

.meas tran vdout0_4ck1280 FIND v(dout0_4) AT=645.025n

.meas tran vdout0_5ck1280 FIND v(dout0_5) AT=645.025n

.meas tran vdout0_6ck1280 FIND v(dout0_6) AT=645.025n

.meas tran vdout0_7ck1280 FIND v(dout0_7) AT=645.025n

.meas tran vdout0_8ck1280 FIND v(dout0_8) AT=645.025n

.meas tran vdout0_9ck1280 FIND v(dout0_9) AT=645.025n

.meas tran vdout0_10ck1280 FIND v(dout0_10) AT=645.025n

.meas tran vdout0_11ck1280 FIND v(dout0_11) AT=645.025n

.meas tran vdout0_12ck1280 FIND v(dout0_12) AT=645.025n

.meas tran vdout0_13ck1280 FIND v(dout0_13) AT=645.025n

.meas tran vdout0_14ck1280 FIND v(dout0_14) AT=645.025n

.meas tran vdout0_15ck1280 FIND v(dout0_15) AT=645.025n

.meas tran vdout0_16ck1280 FIND v(dout0_16) AT=645.025n

.meas tran vdout0_17ck1280 FIND v(dout0_17) AT=645.025n

.meas tran vdout0_18ck1280 FIND v(dout0_18) AT=645.025n

.meas tran vdout0_19ck1280 FIND v(dout0_19) AT=645.025n

.meas tran vdout0_20ck1280 FIND v(dout0_20) AT=645.025n

.meas tran vdout0_21ck1280 FIND v(dout0_21) AT=645.025n

.meas tran vdout0_22ck1280 FIND v(dout0_22) AT=645.025n

.meas tran vdout0_23ck1280 FIND v(dout0_23) AT=645.025n

.meas tran vdout0_24ck1280 FIND v(dout0_24) AT=645.025n

.meas tran vdout0_25ck1280 FIND v(dout0_25) AT=645.025n

.meas tran vdout0_26ck1280 FIND v(dout0_26) AT=645.025n

.meas tran vdout0_27ck1280 FIND v(dout0_27) AT=645.025n

.meas tran vdout0_28ck1280 FIND v(dout0_28) AT=645.025n

.meas tran vdout0_29ck1280 FIND v(dout0_29) AT=645.025n

.meas tran vdout0_30ck1280 FIND v(dout0_30) AT=645.025n

.meas tran vdout0_31ck1280 FIND v(dout0_31) AT=645.025n

.meas tran vdout0_0ck1310 FIND v(dout0_0) AT=660.025n

.meas tran vdout0_1ck1310 FIND v(dout0_1) AT=660.025n

.meas tran vdout0_2ck1310 FIND v(dout0_2) AT=660.025n

.meas tran vdout0_3ck1310 FIND v(dout0_3) AT=660.025n

.meas tran vdout0_4ck1310 FIND v(dout0_4) AT=660.025n

.meas tran vdout0_5ck1310 FIND v(dout0_5) AT=660.025n

.meas tran vdout0_6ck1310 FIND v(dout0_6) AT=660.025n

.meas tran vdout0_7ck1310 FIND v(dout0_7) AT=660.025n

.meas tran vdout0_8ck1310 FIND v(dout0_8) AT=660.025n

.meas tran vdout0_9ck1310 FIND v(dout0_9) AT=660.025n

.meas tran vdout0_10ck1310 FIND v(dout0_10) AT=660.025n

.meas tran vdout0_11ck1310 FIND v(dout0_11) AT=660.025n

.meas tran vdout0_12ck1310 FIND v(dout0_12) AT=660.025n

.meas tran vdout0_13ck1310 FIND v(dout0_13) AT=660.025n

.meas tran vdout0_14ck1310 FIND v(dout0_14) AT=660.025n

.meas tran vdout0_15ck1310 FIND v(dout0_15) AT=660.025n

.meas tran vdout0_16ck1310 FIND v(dout0_16) AT=660.025n

.meas tran vdout0_17ck1310 FIND v(dout0_17) AT=660.025n

.meas tran vdout0_18ck1310 FIND v(dout0_18) AT=660.025n

.meas tran vdout0_19ck1310 FIND v(dout0_19) AT=660.025n

.meas tran vdout0_20ck1310 FIND v(dout0_20) AT=660.025n

.meas tran vdout0_21ck1310 FIND v(dout0_21) AT=660.025n

.meas tran vdout0_22ck1310 FIND v(dout0_22) AT=660.025n

.meas tran vdout0_23ck1310 FIND v(dout0_23) AT=660.025n

.meas tran vdout0_24ck1310 FIND v(dout0_24) AT=660.025n

.meas tran vdout0_25ck1310 FIND v(dout0_25) AT=660.025n

.meas tran vdout0_26ck1310 FIND v(dout0_26) AT=660.025n

.meas tran vdout0_27ck1310 FIND v(dout0_27) AT=660.025n

.meas tran vdout0_28ck1310 FIND v(dout0_28) AT=660.025n

.meas tran vdout0_29ck1310 FIND v(dout0_29) AT=660.025n

.meas tran vdout0_30ck1310 FIND v(dout0_30) AT=660.025n

.meas tran vdout0_31ck1310 FIND v(dout0_31) AT=660.025n

.meas tran vdout0_0ck1330 FIND v(dout0_0) AT=670.025n

.meas tran vdout0_1ck1330 FIND v(dout0_1) AT=670.025n

.meas tran vdout0_2ck1330 FIND v(dout0_2) AT=670.025n

.meas tran vdout0_3ck1330 FIND v(dout0_3) AT=670.025n

.meas tran vdout0_4ck1330 FIND v(dout0_4) AT=670.025n

.meas tran vdout0_5ck1330 FIND v(dout0_5) AT=670.025n

.meas tran vdout0_6ck1330 FIND v(dout0_6) AT=670.025n

.meas tran vdout0_7ck1330 FIND v(dout0_7) AT=670.025n

.meas tran vdout0_8ck1330 FIND v(dout0_8) AT=670.025n

.meas tran vdout0_9ck1330 FIND v(dout0_9) AT=670.025n

.meas tran vdout0_10ck1330 FIND v(dout0_10) AT=670.025n

.meas tran vdout0_11ck1330 FIND v(dout0_11) AT=670.025n

.meas tran vdout0_12ck1330 FIND v(dout0_12) AT=670.025n

.meas tran vdout0_13ck1330 FIND v(dout0_13) AT=670.025n

.meas tran vdout0_14ck1330 FIND v(dout0_14) AT=670.025n

.meas tran vdout0_15ck1330 FIND v(dout0_15) AT=670.025n

.meas tran vdout0_16ck1330 FIND v(dout0_16) AT=670.025n

.meas tran vdout0_17ck1330 FIND v(dout0_17) AT=670.025n

.meas tran vdout0_18ck1330 FIND v(dout0_18) AT=670.025n

.meas tran vdout0_19ck1330 FIND v(dout0_19) AT=670.025n

.meas tran vdout0_20ck1330 FIND v(dout0_20) AT=670.025n

.meas tran vdout0_21ck1330 FIND v(dout0_21) AT=670.025n

.meas tran vdout0_22ck1330 FIND v(dout0_22) AT=670.025n

.meas tran vdout0_23ck1330 FIND v(dout0_23) AT=670.025n

.meas tran vdout0_24ck1330 FIND v(dout0_24) AT=670.025n

.meas tran vdout0_25ck1330 FIND v(dout0_25) AT=670.025n

.meas tran vdout0_26ck1330 FIND v(dout0_26) AT=670.025n

.meas tran vdout0_27ck1330 FIND v(dout0_27) AT=670.025n

.meas tran vdout0_28ck1330 FIND v(dout0_28) AT=670.025n

.meas tran vdout0_29ck1330 FIND v(dout0_29) AT=670.025n

.meas tran vdout0_30ck1330 FIND v(dout0_30) AT=670.025n

.meas tran vdout0_31ck1330 FIND v(dout0_31) AT=670.025n

.meas tran vdout0_0ck1340 FIND v(dout0_0) AT=675.025n

.meas tran vdout0_1ck1340 FIND v(dout0_1) AT=675.025n

.meas tran vdout0_2ck1340 FIND v(dout0_2) AT=675.025n

.meas tran vdout0_3ck1340 FIND v(dout0_3) AT=675.025n

.meas tran vdout0_4ck1340 FIND v(dout0_4) AT=675.025n

.meas tran vdout0_5ck1340 FIND v(dout0_5) AT=675.025n

.meas tran vdout0_6ck1340 FIND v(dout0_6) AT=675.025n

.meas tran vdout0_7ck1340 FIND v(dout0_7) AT=675.025n

.meas tran vdout0_8ck1340 FIND v(dout0_8) AT=675.025n

.meas tran vdout0_9ck1340 FIND v(dout0_9) AT=675.025n

.meas tran vdout0_10ck1340 FIND v(dout0_10) AT=675.025n

.meas tran vdout0_11ck1340 FIND v(dout0_11) AT=675.025n

.meas tran vdout0_12ck1340 FIND v(dout0_12) AT=675.025n

.meas tran vdout0_13ck1340 FIND v(dout0_13) AT=675.025n

.meas tran vdout0_14ck1340 FIND v(dout0_14) AT=675.025n

.meas tran vdout0_15ck1340 FIND v(dout0_15) AT=675.025n

.meas tran vdout0_16ck1340 FIND v(dout0_16) AT=675.025n

.meas tran vdout0_17ck1340 FIND v(dout0_17) AT=675.025n

.meas tran vdout0_18ck1340 FIND v(dout0_18) AT=675.025n

.meas tran vdout0_19ck1340 FIND v(dout0_19) AT=675.025n

.meas tran vdout0_20ck1340 FIND v(dout0_20) AT=675.025n

.meas tran vdout0_21ck1340 FIND v(dout0_21) AT=675.025n

.meas tran vdout0_22ck1340 FIND v(dout0_22) AT=675.025n

.meas tran vdout0_23ck1340 FIND v(dout0_23) AT=675.025n

.meas tran vdout0_24ck1340 FIND v(dout0_24) AT=675.025n

.meas tran vdout0_25ck1340 FIND v(dout0_25) AT=675.025n

.meas tran vdout0_26ck1340 FIND v(dout0_26) AT=675.025n

.meas tran vdout0_27ck1340 FIND v(dout0_27) AT=675.025n

.meas tran vdout0_28ck1340 FIND v(dout0_28) AT=675.025n

.meas tran vdout0_29ck1340 FIND v(dout0_29) AT=675.025n

.meas tran vdout0_30ck1340 FIND v(dout0_30) AT=675.025n

.meas tran vdout0_31ck1340 FIND v(dout0_31) AT=675.025n

.meas tran vdout0_0ck1350 FIND v(dout0_0) AT=680.025n

.meas tran vdout0_1ck1350 FIND v(dout0_1) AT=680.025n

.meas tran vdout0_2ck1350 FIND v(dout0_2) AT=680.025n

.meas tran vdout0_3ck1350 FIND v(dout0_3) AT=680.025n

.meas tran vdout0_4ck1350 FIND v(dout0_4) AT=680.025n

.meas tran vdout0_5ck1350 FIND v(dout0_5) AT=680.025n

.meas tran vdout0_6ck1350 FIND v(dout0_6) AT=680.025n

.meas tran vdout0_7ck1350 FIND v(dout0_7) AT=680.025n

.meas tran vdout0_8ck1350 FIND v(dout0_8) AT=680.025n

.meas tran vdout0_9ck1350 FIND v(dout0_9) AT=680.025n

.meas tran vdout0_10ck1350 FIND v(dout0_10) AT=680.025n

.meas tran vdout0_11ck1350 FIND v(dout0_11) AT=680.025n

.meas tran vdout0_12ck1350 FIND v(dout0_12) AT=680.025n

.meas tran vdout0_13ck1350 FIND v(dout0_13) AT=680.025n

.meas tran vdout0_14ck1350 FIND v(dout0_14) AT=680.025n

.meas tran vdout0_15ck1350 FIND v(dout0_15) AT=680.025n

.meas tran vdout0_16ck1350 FIND v(dout0_16) AT=680.025n

.meas tran vdout0_17ck1350 FIND v(dout0_17) AT=680.025n

.meas tran vdout0_18ck1350 FIND v(dout0_18) AT=680.025n

.meas tran vdout0_19ck1350 FIND v(dout0_19) AT=680.025n

.meas tran vdout0_20ck1350 FIND v(dout0_20) AT=680.025n

.meas tran vdout0_21ck1350 FIND v(dout0_21) AT=680.025n

.meas tran vdout0_22ck1350 FIND v(dout0_22) AT=680.025n

.meas tran vdout0_23ck1350 FIND v(dout0_23) AT=680.025n

.meas tran vdout0_24ck1350 FIND v(dout0_24) AT=680.025n

.meas tran vdout0_25ck1350 FIND v(dout0_25) AT=680.025n

.meas tran vdout0_26ck1350 FIND v(dout0_26) AT=680.025n

.meas tran vdout0_27ck1350 FIND v(dout0_27) AT=680.025n

.meas tran vdout0_28ck1350 FIND v(dout0_28) AT=680.025n

.meas tran vdout0_29ck1350 FIND v(dout0_29) AT=680.025n

.meas tran vdout0_30ck1350 FIND v(dout0_30) AT=680.025n

.meas tran vdout0_31ck1350 FIND v(dout0_31) AT=680.025n

.meas tran vdout0_0ck1360 FIND v(dout0_0) AT=685.025n

.meas tran vdout0_1ck1360 FIND v(dout0_1) AT=685.025n

.meas tran vdout0_2ck1360 FIND v(dout0_2) AT=685.025n

.meas tran vdout0_3ck1360 FIND v(dout0_3) AT=685.025n

.meas tran vdout0_4ck1360 FIND v(dout0_4) AT=685.025n

.meas tran vdout0_5ck1360 FIND v(dout0_5) AT=685.025n

.meas tran vdout0_6ck1360 FIND v(dout0_6) AT=685.025n

.meas tran vdout0_7ck1360 FIND v(dout0_7) AT=685.025n

.meas tran vdout0_8ck1360 FIND v(dout0_8) AT=685.025n

.meas tran vdout0_9ck1360 FIND v(dout0_9) AT=685.025n

.meas tran vdout0_10ck1360 FIND v(dout0_10) AT=685.025n

.meas tran vdout0_11ck1360 FIND v(dout0_11) AT=685.025n

.meas tran vdout0_12ck1360 FIND v(dout0_12) AT=685.025n

.meas tran vdout0_13ck1360 FIND v(dout0_13) AT=685.025n

.meas tran vdout0_14ck1360 FIND v(dout0_14) AT=685.025n

.meas tran vdout0_15ck1360 FIND v(dout0_15) AT=685.025n

.meas tran vdout0_16ck1360 FIND v(dout0_16) AT=685.025n

.meas tran vdout0_17ck1360 FIND v(dout0_17) AT=685.025n

.meas tran vdout0_18ck1360 FIND v(dout0_18) AT=685.025n

.meas tran vdout0_19ck1360 FIND v(dout0_19) AT=685.025n

.meas tran vdout0_20ck1360 FIND v(dout0_20) AT=685.025n

.meas tran vdout0_21ck1360 FIND v(dout0_21) AT=685.025n

.meas tran vdout0_22ck1360 FIND v(dout0_22) AT=685.025n

.meas tran vdout0_23ck1360 FIND v(dout0_23) AT=685.025n

.meas tran vdout0_24ck1360 FIND v(dout0_24) AT=685.025n

.meas tran vdout0_25ck1360 FIND v(dout0_25) AT=685.025n

.meas tran vdout0_26ck1360 FIND v(dout0_26) AT=685.025n

.meas tran vdout0_27ck1360 FIND v(dout0_27) AT=685.025n

.meas tran vdout0_28ck1360 FIND v(dout0_28) AT=685.025n

.meas tran vdout0_29ck1360 FIND v(dout0_29) AT=685.025n

.meas tran vdout0_30ck1360 FIND v(dout0_30) AT=685.025n

.meas tran vdout0_31ck1360 FIND v(dout0_31) AT=685.025n

.meas tran vdout0_0ck1370 FIND v(dout0_0) AT=690.025n

.meas tran vdout0_1ck1370 FIND v(dout0_1) AT=690.025n

.meas tran vdout0_2ck1370 FIND v(dout0_2) AT=690.025n

.meas tran vdout0_3ck1370 FIND v(dout0_3) AT=690.025n

.meas tran vdout0_4ck1370 FIND v(dout0_4) AT=690.025n

.meas tran vdout0_5ck1370 FIND v(dout0_5) AT=690.025n

.meas tran vdout0_6ck1370 FIND v(dout0_6) AT=690.025n

.meas tran vdout0_7ck1370 FIND v(dout0_7) AT=690.025n

.meas tran vdout0_8ck1370 FIND v(dout0_8) AT=690.025n

.meas tran vdout0_9ck1370 FIND v(dout0_9) AT=690.025n

.meas tran vdout0_10ck1370 FIND v(dout0_10) AT=690.025n

.meas tran vdout0_11ck1370 FIND v(dout0_11) AT=690.025n

.meas tran vdout0_12ck1370 FIND v(dout0_12) AT=690.025n

.meas tran vdout0_13ck1370 FIND v(dout0_13) AT=690.025n

.meas tran vdout0_14ck1370 FIND v(dout0_14) AT=690.025n

.meas tran vdout0_15ck1370 FIND v(dout0_15) AT=690.025n

.meas tran vdout0_16ck1370 FIND v(dout0_16) AT=690.025n

.meas tran vdout0_17ck1370 FIND v(dout0_17) AT=690.025n

.meas tran vdout0_18ck1370 FIND v(dout0_18) AT=690.025n

.meas tran vdout0_19ck1370 FIND v(dout0_19) AT=690.025n

.meas tran vdout0_20ck1370 FIND v(dout0_20) AT=690.025n

.meas tran vdout0_21ck1370 FIND v(dout0_21) AT=690.025n

.meas tran vdout0_22ck1370 FIND v(dout0_22) AT=690.025n

.meas tran vdout0_23ck1370 FIND v(dout0_23) AT=690.025n

.meas tran vdout0_24ck1370 FIND v(dout0_24) AT=690.025n

.meas tran vdout0_25ck1370 FIND v(dout0_25) AT=690.025n

.meas tran vdout0_26ck1370 FIND v(dout0_26) AT=690.025n

.meas tran vdout0_27ck1370 FIND v(dout0_27) AT=690.025n

.meas tran vdout0_28ck1370 FIND v(dout0_28) AT=690.025n

.meas tran vdout0_29ck1370 FIND v(dout0_29) AT=690.025n

.meas tran vdout0_30ck1370 FIND v(dout0_30) AT=690.025n

.meas tran vdout0_31ck1370 FIND v(dout0_31) AT=690.025n

.meas tran vdout0_0ck1380 FIND v(dout0_0) AT=695.025n

.meas tran vdout0_1ck1380 FIND v(dout0_1) AT=695.025n

.meas tran vdout0_2ck1380 FIND v(dout0_2) AT=695.025n

.meas tran vdout0_3ck1380 FIND v(dout0_3) AT=695.025n

.meas tran vdout0_4ck1380 FIND v(dout0_4) AT=695.025n

.meas tran vdout0_5ck1380 FIND v(dout0_5) AT=695.025n

.meas tran vdout0_6ck1380 FIND v(dout0_6) AT=695.025n

.meas tran vdout0_7ck1380 FIND v(dout0_7) AT=695.025n

.meas tran vdout0_8ck1380 FIND v(dout0_8) AT=695.025n

.meas tran vdout0_9ck1380 FIND v(dout0_9) AT=695.025n

.meas tran vdout0_10ck1380 FIND v(dout0_10) AT=695.025n

.meas tran vdout0_11ck1380 FIND v(dout0_11) AT=695.025n

.meas tran vdout0_12ck1380 FIND v(dout0_12) AT=695.025n

.meas tran vdout0_13ck1380 FIND v(dout0_13) AT=695.025n

.meas tran vdout0_14ck1380 FIND v(dout0_14) AT=695.025n

.meas tran vdout0_15ck1380 FIND v(dout0_15) AT=695.025n

.meas tran vdout0_16ck1380 FIND v(dout0_16) AT=695.025n

.meas tran vdout0_17ck1380 FIND v(dout0_17) AT=695.025n

.meas tran vdout0_18ck1380 FIND v(dout0_18) AT=695.025n

.meas tran vdout0_19ck1380 FIND v(dout0_19) AT=695.025n

.meas tran vdout0_20ck1380 FIND v(dout0_20) AT=695.025n

.meas tran vdout0_21ck1380 FIND v(dout0_21) AT=695.025n

.meas tran vdout0_22ck1380 FIND v(dout0_22) AT=695.025n

.meas tran vdout0_23ck1380 FIND v(dout0_23) AT=695.025n

.meas tran vdout0_24ck1380 FIND v(dout0_24) AT=695.025n

.meas tran vdout0_25ck1380 FIND v(dout0_25) AT=695.025n

.meas tran vdout0_26ck1380 FIND v(dout0_26) AT=695.025n

.meas tran vdout0_27ck1380 FIND v(dout0_27) AT=695.025n

.meas tran vdout0_28ck1380 FIND v(dout0_28) AT=695.025n

.meas tran vdout0_29ck1380 FIND v(dout0_29) AT=695.025n

.meas tran vdout0_30ck1380 FIND v(dout0_30) AT=695.025n

.meas tran vdout0_31ck1380 FIND v(dout0_31) AT=695.025n

.meas tran vdout0_0ck1390 FIND v(dout0_0) AT=700.025n

.meas tran vdout0_1ck1390 FIND v(dout0_1) AT=700.025n

.meas tran vdout0_2ck1390 FIND v(dout0_2) AT=700.025n

.meas tran vdout0_3ck1390 FIND v(dout0_3) AT=700.025n

.meas tran vdout0_4ck1390 FIND v(dout0_4) AT=700.025n

.meas tran vdout0_5ck1390 FIND v(dout0_5) AT=700.025n

.meas tran vdout0_6ck1390 FIND v(dout0_6) AT=700.025n

.meas tran vdout0_7ck1390 FIND v(dout0_7) AT=700.025n

.meas tran vdout0_8ck1390 FIND v(dout0_8) AT=700.025n

.meas tran vdout0_9ck1390 FIND v(dout0_9) AT=700.025n

.meas tran vdout0_10ck1390 FIND v(dout0_10) AT=700.025n

.meas tran vdout0_11ck1390 FIND v(dout0_11) AT=700.025n

.meas tran vdout0_12ck1390 FIND v(dout0_12) AT=700.025n

.meas tran vdout0_13ck1390 FIND v(dout0_13) AT=700.025n

.meas tran vdout0_14ck1390 FIND v(dout0_14) AT=700.025n

.meas tran vdout0_15ck1390 FIND v(dout0_15) AT=700.025n

.meas tran vdout0_16ck1390 FIND v(dout0_16) AT=700.025n

.meas tran vdout0_17ck1390 FIND v(dout0_17) AT=700.025n

.meas tran vdout0_18ck1390 FIND v(dout0_18) AT=700.025n

.meas tran vdout0_19ck1390 FIND v(dout0_19) AT=700.025n

.meas tran vdout0_20ck1390 FIND v(dout0_20) AT=700.025n

.meas tran vdout0_21ck1390 FIND v(dout0_21) AT=700.025n

.meas tran vdout0_22ck1390 FIND v(dout0_22) AT=700.025n

.meas tran vdout0_23ck1390 FIND v(dout0_23) AT=700.025n

.meas tran vdout0_24ck1390 FIND v(dout0_24) AT=700.025n

.meas tran vdout0_25ck1390 FIND v(dout0_25) AT=700.025n

.meas tran vdout0_26ck1390 FIND v(dout0_26) AT=700.025n

.meas tran vdout0_27ck1390 FIND v(dout0_27) AT=700.025n

.meas tran vdout0_28ck1390 FIND v(dout0_28) AT=700.025n

.meas tran vdout0_29ck1390 FIND v(dout0_29) AT=700.025n

.meas tran vdout0_30ck1390 FIND v(dout0_30) AT=700.025n

.meas tran vdout0_31ck1390 FIND v(dout0_31) AT=700.025n

.meas tran vdout0_0ck1410 FIND v(dout0_0) AT=710.025n

.meas tran vdout0_1ck1410 FIND v(dout0_1) AT=710.025n

.meas tran vdout0_2ck1410 FIND v(dout0_2) AT=710.025n

.meas tran vdout0_3ck1410 FIND v(dout0_3) AT=710.025n

.meas tran vdout0_4ck1410 FIND v(dout0_4) AT=710.025n

.meas tran vdout0_5ck1410 FIND v(dout0_5) AT=710.025n

.meas tran vdout0_6ck1410 FIND v(dout0_6) AT=710.025n

.meas tran vdout0_7ck1410 FIND v(dout0_7) AT=710.025n

.meas tran vdout0_8ck1410 FIND v(dout0_8) AT=710.025n

.meas tran vdout0_9ck1410 FIND v(dout0_9) AT=710.025n

.meas tran vdout0_10ck1410 FIND v(dout0_10) AT=710.025n

.meas tran vdout0_11ck1410 FIND v(dout0_11) AT=710.025n

.meas tran vdout0_12ck1410 FIND v(dout0_12) AT=710.025n

.meas tran vdout0_13ck1410 FIND v(dout0_13) AT=710.025n

.meas tran vdout0_14ck1410 FIND v(dout0_14) AT=710.025n

.meas tran vdout0_15ck1410 FIND v(dout0_15) AT=710.025n

.meas tran vdout0_16ck1410 FIND v(dout0_16) AT=710.025n

.meas tran vdout0_17ck1410 FIND v(dout0_17) AT=710.025n

.meas tran vdout0_18ck1410 FIND v(dout0_18) AT=710.025n

.meas tran vdout0_19ck1410 FIND v(dout0_19) AT=710.025n

.meas tran vdout0_20ck1410 FIND v(dout0_20) AT=710.025n

.meas tran vdout0_21ck1410 FIND v(dout0_21) AT=710.025n

.meas tran vdout0_22ck1410 FIND v(dout0_22) AT=710.025n

.meas tran vdout0_23ck1410 FIND v(dout0_23) AT=710.025n

.meas tran vdout0_24ck1410 FIND v(dout0_24) AT=710.025n

.meas tran vdout0_25ck1410 FIND v(dout0_25) AT=710.025n

.meas tran vdout0_26ck1410 FIND v(dout0_26) AT=710.025n

.meas tran vdout0_27ck1410 FIND v(dout0_27) AT=710.025n

.meas tran vdout0_28ck1410 FIND v(dout0_28) AT=710.025n

.meas tran vdout0_29ck1410 FIND v(dout0_29) AT=710.025n

.meas tran vdout0_30ck1410 FIND v(dout0_30) AT=710.025n

.meas tran vdout0_31ck1410 FIND v(dout0_31) AT=710.025n

.meas tran vdout0_0ck1420 FIND v(dout0_0) AT=715.025n

.meas tran vdout0_1ck1420 FIND v(dout0_1) AT=715.025n

.meas tran vdout0_2ck1420 FIND v(dout0_2) AT=715.025n

.meas tran vdout0_3ck1420 FIND v(dout0_3) AT=715.025n

.meas tran vdout0_4ck1420 FIND v(dout0_4) AT=715.025n

.meas tran vdout0_5ck1420 FIND v(dout0_5) AT=715.025n

.meas tran vdout0_6ck1420 FIND v(dout0_6) AT=715.025n

.meas tran vdout0_7ck1420 FIND v(dout0_7) AT=715.025n

.meas tran vdout0_8ck1420 FIND v(dout0_8) AT=715.025n

.meas tran vdout0_9ck1420 FIND v(dout0_9) AT=715.025n

.meas tran vdout0_10ck1420 FIND v(dout0_10) AT=715.025n

.meas tran vdout0_11ck1420 FIND v(dout0_11) AT=715.025n

.meas tran vdout0_12ck1420 FIND v(dout0_12) AT=715.025n

.meas tran vdout0_13ck1420 FIND v(dout0_13) AT=715.025n

.meas tran vdout0_14ck1420 FIND v(dout0_14) AT=715.025n

.meas tran vdout0_15ck1420 FIND v(dout0_15) AT=715.025n

.meas tran vdout0_16ck1420 FIND v(dout0_16) AT=715.025n

.meas tran vdout0_17ck1420 FIND v(dout0_17) AT=715.025n

.meas tran vdout0_18ck1420 FIND v(dout0_18) AT=715.025n

.meas tran vdout0_19ck1420 FIND v(dout0_19) AT=715.025n

.meas tran vdout0_20ck1420 FIND v(dout0_20) AT=715.025n

.meas tran vdout0_21ck1420 FIND v(dout0_21) AT=715.025n

.meas tran vdout0_22ck1420 FIND v(dout0_22) AT=715.025n

.meas tran vdout0_23ck1420 FIND v(dout0_23) AT=715.025n

.meas tran vdout0_24ck1420 FIND v(dout0_24) AT=715.025n

.meas tran vdout0_25ck1420 FIND v(dout0_25) AT=715.025n

.meas tran vdout0_26ck1420 FIND v(dout0_26) AT=715.025n

.meas tran vdout0_27ck1420 FIND v(dout0_27) AT=715.025n

.meas tran vdout0_28ck1420 FIND v(dout0_28) AT=715.025n

.meas tran vdout0_29ck1420 FIND v(dout0_29) AT=715.025n

.meas tran vdout0_30ck1420 FIND v(dout0_30) AT=715.025n

.meas tran vdout0_31ck1420 FIND v(dout0_31) AT=715.025n

.meas tran vdout0_0ck1430 FIND v(dout0_0) AT=720.025n

.meas tran vdout0_1ck1430 FIND v(dout0_1) AT=720.025n

.meas tran vdout0_2ck1430 FIND v(dout0_2) AT=720.025n

.meas tran vdout0_3ck1430 FIND v(dout0_3) AT=720.025n

.meas tran vdout0_4ck1430 FIND v(dout0_4) AT=720.025n

.meas tran vdout0_5ck1430 FIND v(dout0_5) AT=720.025n

.meas tran vdout0_6ck1430 FIND v(dout0_6) AT=720.025n

.meas tran vdout0_7ck1430 FIND v(dout0_7) AT=720.025n

.meas tran vdout0_8ck1430 FIND v(dout0_8) AT=720.025n

.meas tran vdout0_9ck1430 FIND v(dout0_9) AT=720.025n

.meas tran vdout0_10ck1430 FIND v(dout0_10) AT=720.025n

.meas tran vdout0_11ck1430 FIND v(dout0_11) AT=720.025n

.meas tran vdout0_12ck1430 FIND v(dout0_12) AT=720.025n

.meas tran vdout0_13ck1430 FIND v(dout0_13) AT=720.025n

.meas tran vdout0_14ck1430 FIND v(dout0_14) AT=720.025n

.meas tran vdout0_15ck1430 FIND v(dout0_15) AT=720.025n

.meas tran vdout0_16ck1430 FIND v(dout0_16) AT=720.025n

.meas tran vdout0_17ck1430 FIND v(dout0_17) AT=720.025n

.meas tran vdout0_18ck1430 FIND v(dout0_18) AT=720.025n

.meas tran vdout0_19ck1430 FIND v(dout0_19) AT=720.025n

.meas tran vdout0_20ck1430 FIND v(dout0_20) AT=720.025n

.meas tran vdout0_21ck1430 FIND v(dout0_21) AT=720.025n

.meas tran vdout0_22ck1430 FIND v(dout0_22) AT=720.025n

.meas tran vdout0_23ck1430 FIND v(dout0_23) AT=720.025n

.meas tran vdout0_24ck1430 FIND v(dout0_24) AT=720.025n

.meas tran vdout0_25ck1430 FIND v(dout0_25) AT=720.025n

.meas tran vdout0_26ck1430 FIND v(dout0_26) AT=720.025n

.meas tran vdout0_27ck1430 FIND v(dout0_27) AT=720.025n

.meas tran vdout0_28ck1430 FIND v(dout0_28) AT=720.025n

.meas tran vdout0_29ck1430 FIND v(dout0_29) AT=720.025n

.meas tran vdout0_30ck1430 FIND v(dout0_30) AT=720.025n

.meas tran vdout0_31ck1430 FIND v(dout0_31) AT=720.025n

.meas tran vdout0_0ck1470 FIND v(dout0_0) AT=740.025n

.meas tran vdout0_1ck1470 FIND v(dout0_1) AT=740.025n

.meas tran vdout0_2ck1470 FIND v(dout0_2) AT=740.025n

.meas tran vdout0_3ck1470 FIND v(dout0_3) AT=740.025n

.meas tran vdout0_4ck1470 FIND v(dout0_4) AT=740.025n

.meas tran vdout0_5ck1470 FIND v(dout0_5) AT=740.025n

.meas tran vdout0_6ck1470 FIND v(dout0_6) AT=740.025n

.meas tran vdout0_7ck1470 FIND v(dout0_7) AT=740.025n

.meas tran vdout0_8ck1470 FIND v(dout0_8) AT=740.025n

.meas tran vdout0_9ck1470 FIND v(dout0_9) AT=740.025n

.meas tran vdout0_10ck1470 FIND v(dout0_10) AT=740.025n

.meas tran vdout0_11ck1470 FIND v(dout0_11) AT=740.025n

.meas tran vdout0_12ck1470 FIND v(dout0_12) AT=740.025n

.meas tran vdout0_13ck1470 FIND v(dout0_13) AT=740.025n

.meas tran vdout0_14ck1470 FIND v(dout0_14) AT=740.025n

.meas tran vdout0_15ck1470 FIND v(dout0_15) AT=740.025n

.meas tran vdout0_16ck1470 FIND v(dout0_16) AT=740.025n

.meas tran vdout0_17ck1470 FIND v(dout0_17) AT=740.025n

.meas tran vdout0_18ck1470 FIND v(dout0_18) AT=740.025n

.meas tran vdout0_19ck1470 FIND v(dout0_19) AT=740.025n

.meas tran vdout0_20ck1470 FIND v(dout0_20) AT=740.025n

.meas tran vdout0_21ck1470 FIND v(dout0_21) AT=740.025n

.meas tran vdout0_22ck1470 FIND v(dout0_22) AT=740.025n

.meas tran vdout0_23ck1470 FIND v(dout0_23) AT=740.025n

.meas tran vdout0_24ck1470 FIND v(dout0_24) AT=740.025n

.meas tran vdout0_25ck1470 FIND v(dout0_25) AT=740.025n

.meas tran vdout0_26ck1470 FIND v(dout0_26) AT=740.025n

.meas tran vdout0_27ck1470 FIND v(dout0_27) AT=740.025n

.meas tran vdout0_28ck1470 FIND v(dout0_28) AT=740.025n

.meas tran vdout0_29ck1470 FIND v(dout0_29) AT=740.025n

.meas tran vdout0_30ck1470 FIND v(dout0_30) AT=740.025n

.meas tran vdout0_31ck1470 FIND v(dout0_31) AT=740.025n

.meas tran vdout0_0ck1490 FIND v(dout0_0) AT=750.025n

.meas tran vdout0_1ck1490 FIND v(dout0_1) AT=750.025n

.meas tran vdout0_2ck1490 FIND v(dout0_2) AT=750.025n

.meas tran vdout0_3ck1490 FIND v(dout0_3) AT=750.025n

.meas tran vdout0_4ck1490 FIND v(dout0_4) AT=750.025n

.meas tran vdout0_5ck1490 FIND v(dout0_5) AT=750.025n

.meas tran vdout0_6ck1490 FIND v(dout0_6) AT=750.025n

.meas tran vdout0_7ck1490 FIND v(dout0_7) AT=750.025n

.meas tran vdout0_8ck1490 FIND v(dout0_8) AT=750.025n

.meas tran vdout0_9ck1490 FIND v(dout0_9) AT=750.025n

.meas tran vdout0_10ck1490 FIND v(dout0_10) AT=750.025n

.meas tran vdout0_11ck1490 FIND v(dout0_11) AT=750.025n

.meas tran vdout0_12ck1490 FIND v(dout0_12) AT=750.025n

.meas tran vdout0_13ck1490 FIND v(dout0_13) AT=750.025n

.meas tran vdout0_14ck1490 FIND v(dout0_14) AT=750.025n

.meas tran vdout0_15ck1490 FIND v(dout0_15) AT=750.025n

.meas tran vdout0_16ck1490 FIND v(dout0_16) AT=750.025n

.meas tran vdout0_17ck1490 FIND v(dout0_17) AT=750.025n

.meas tran vdout0_18ck1490 FIND v(dout0_18) AT=750.025n

.meas tran vdout0_19ck1490 FIND v(dout0_19) AT=750.025n

.meas tran vdout0_20ck1490 FIND v(dout0_20) AT=750.025n

.meas tran vdout0_21ck1490 FIND v(dout0_21) AT=750.025n

.meas tran vdout0_22ck1490 FIND v(dout0_22) AT=750.025n

.meas tran vdout0_23ck1490 FIND v(dout0_23) AT=750.025n

.meas tran vdout0_24ck1490 FIND v(dout0_24) AT=750.025n

.meas tran vdout0_25ck1490 FIND v(dout0_25) AT=750.025n

.meas tran vdout0_26ck1490 FIND v(dout0_26) AT=750.025n

.meas tran vdout0_27ck1490 FIND v(dout0_27) AT=750.025n

.meas tran vdout0_28ck1490 FIND v(dout0_28) AT=750.025n

.meas tran vdout0_29ck1490 FIND v(dout0_29) AT=750.025n

.meas tran vdout0_30ck1490 FIND v(dout0_30) AT=750.025n

.meas tran vdout0_31ck1490 FIND v(dout0_31) AT=750.025n

.meas tran vdout0_0ck1510 FIND v(dout0_0) AT=760.025n

.meas tran vdout0_1ck1510 FIND v(dout0_1) AT=760.025n

.meas tran vdout0_2ck1510 FIND v(dout0_2) AT=760.025n

.meas tran vdout0_3ck1510 FIND v(dout0_3) AT=760.025n

.meas tran vdout0_4ck1510 FIND v(dout0_4) AT=760.025n

.meas tran vdout0_5ck1510 FIND v(dout0_5) AT=760.025n

.meas tran vdout0_6ck1510 FIND v(dout0_6) AT=760.025n

.meas tran vdout0_7ck1510 FIND v(dout0_7) AT=760.025n

.meas tran vdout0_8ck1510 FIND v(dout0_8) AT=760.025n

.meas tran vdout0_9ck1510 FIND v(dout0_9) AT=760.025n

.meas tran vdout0_10ck1510 FIND v(dout0_10) AT=760.025n

.meas tran vdout0_11ck1510 FIND v(dout0_11) AT=760.025n

.meas tran vdout0_12ck1510 FIND v(dout0_12) AT=760.025n

.meas tran vdout0_13ck1510 FIND v(dout0_13) AT=760.025n

.meas tran vdout0_14ck1510 FIND v(dout0_14) AT=760.025n

.meas tran vdout0_15ck1510 FIND v(dout0_15) AT=760.025n

.meas tran vdout0_16ck1510 FIND v(dout0_16) AT=760.025n

.meas tran vdout0_17ck1510 FIND v(dout0_17) AT=760.025n

.meas tran vdout0_18ck1510 FIND v(dout0_18) AT=760.025n

.meas tran vdout0_19ck1510 FIND v(dout0_19) AT=760.025n

.meas tran vdout0_20ck1510 FIND v(dout0_20) AT=760.025n

.meas tran vdout0_21ck1510 FIND v(dout0_21) AT=760.025n

.meas tran vdout0_22ck1510 FIND v(dout0_22) AT=760.025n

.meas tran vdout0_23ck1510 FIND v(dout0_23) AT=760.025n

.meas tran vdout0_24ck1510 FIND v(dout0_24) AT=760.025n

.meas tran vdout0_25ck1510 FIND v(dout0_25) AT=760.025n

.meas tran vdout0_26ck1510 FIND v(dout0_26) AT=760.025n

.meas tran vdout0_27ck1510 FIND v(dout0_27) AT=760.025n

.meas tran vdout0_28ck1510 FIND v(dout0_28) AT=760.025n

.meas tran vdout0_29ck1510 FIND v(dout0_29) AT=760.025n

.meas tran vdout0_30ck1510 FIND v(dout0_30) AT=760.025n

.meas tran vdout0_31ck1510 FIND v(dout0_31) AT=760.025n

.meas tran vdout0_0ck1540 FIND v(dout0_0) AT=775.025n

.meas tran vdout0_1ck1540 FIND v(dout0_1) AT=775.025n

.meas tran vdout0_2ck1540 FIND v(dout0_2) AT=775.025n

.meas tran vdout0_3ck1540 FIND v(dout0_3) AT=775.025n

.meas tran vdout0_4ck1540 FIND v(dout0_4) AT=775.025n

.meas tran vdout0_5ck1540 FIND v(dout0_5) AT=775.025n

.meas tran vdout0_6ck1540 FIND v(dout0_6) AT=775.025n

.meas tran vdout0_7ck1540 FIND v(dout0_7) AT=775.025n

.meas tran vdout0_8ck1540 FIND v(dout0_8) AT=775.025n

.meas tran vdout0_9ck1540 FIND v(dout0_9) AT=775.025n

.meas tran vdout0_10ck1540 FIND v(dout0_10) AT=775.025n

.meas tran vdout0_11ck1540 FIND v(dout0_11) AT=775.025n

.meas tran vdout0_12ck1540 FIND v(dout0_12) AT=775.025n

.meas tran vdout0_13ck1540 FIND v(dout0_13) AT=775.025n

.meas tran vdout0_14ck1540 FIND v(dout0_14) AT=775.025n

.meas tran vdout0_15ck1540 FIND v(dout0_15) AT=775.025n

.meas tran vdout0_16ck1540 FIND v(dout0_16) AT=775.025n

.meas tran vdout0_17ck1540 FIND v(dout0_17) AT=775.025n

.meas tran vdout0_18ck1540 FIND v(dout0_18) AT=775.025n

.meas tran vdout0_19ck1540 FIND v(dout0_19) AT=775.025n

.meas tran vdout0_20ck1540 FIND v(dout0_20) AT=775.025n

.meas tran vdout0_21ck1540 FIND v(dout0_21) AT=775.025n

.meas tran vdout0_22ck1540 FIND v(dout0_22) AT=775.025n

.meas tran vdout0_23ck1540 FIND v(dout0_23) AT=775.025n

.meas tran vdout0_24ck1540 FIND v(dout0_24) AT=775.025n

.meas tran vdout0_25ck1540 FIND v(dout0_25) AT=775.025n

.meas tran vdout0_26ck1540 FIND v(dout0_26) AT=775.025n

.meas tran vdout0_27ck1540 FIND v(dout0_27) AT=775.025n

.meas tran vdout0_28ck1540 FIND v(dout0_28) AT=775.025n

.meas tran vdout0_29ck1540 FIND v(dout0_29) AT=775.025n

.meas tran vdout0_30ck1540 FIND v(dout0_30) AT=775.025n

.meas tran vdout0_31ck1540 FIND v(dout0_31) AT=775.025n

.meas tran vdout0_0ck1550 FIND v(dout0_0) AT=780.025n

.meas tran vdout0_1ck1550 FIND v(dout0_1) AT=780.025n

.meas tran vdout0_2ck1550 FIND v(dout0_2) AT=780.025n

.meas tran vdout0_3ck1550 FIND v(dout0_3) AT=780.025n

.meas tran vdout0_4ck1550 FIND v(dout0_4) AT=780.025n

.meas tran vdout0_5ck1550 FIND v(dout0_5) AT=780.025n

.meas tran vdout0_6ck1550 FIND v(dout0_6) AT=780.025n

.meas tran vdout0_7ck1550 FIND v(dout0_7) AT=780.025n

.meas tran vdout0_8ck1550 FIND v(dout0_8) AT=780.025n

.meas tran vdout0_9ck1550 FIND v(dout0_9) AT=780.025n

.meas tran vdout0_10ck1550 FIND v(dout0_10) AT=780.025n

.meas tran vdout0_11ck1550 FIND v(dout0_11) AT=780.025n

.meas tran vdout0_12ck1550 FIND v(dout0_12) AT=780.025n

.meas tran vdout0_13ck1550 FIND v(dout0_13) AT=780.025n

.meas tran vdout0_14ck1550 FIND v(dout0_14) AT=780.025n

.meas tran vdout0_15ck1550 FIND v(dout0_15) AT=780.025n

.meas tran vdout0_16ck1550 FIND v(dout0_16) AT=780.025n

.meas tran vdout0_17ck1550 FIND v(dout0_17) AT=780.025n

.meas tran vdout0_18ck1550 FIND v(dout0_18) AT=780.025n

.meas tran vdout0_19ck1550 FIND v(dout0_19) AT=780.025n

.meas tran vdout0_20ck1550 FIND v(dout0_20) AT=780.025n

.meas tran vdout0_21ck1550 FIND v(dout0_21) AT=780.025n

.meas tran vdout0_22ck1550 FIND v(dout0_22) AT=780.025n

.meas tran vdout0_23ck1550 FIND v(dout0_23) AT=780.025n

.meas tran vdout0_24ck1550 FIND v(dout0_24) AT=780.025n

.meas tran vdout0_25ck1550 FIND v(dout0_25) AT=780.025n

.meas tran vdout0_26ck1550 FIND v(dout0_26) AT=780.025n

.meas tran vdout0_27ck1550 FIND v(dout0_27) AT=780.025n

.meas tran vdout0_28ck1550 FIND v(dout0_28) AT=780.025n

.meas tran vdout0_29ck1550 FIND v(dout0_29) AT=780.025n

.meas tran vdout0_30ck1550 FIND v(dout0_30) AT=780.025n

.meas tran vdout0_31ck1550 FIND v(dout0_31) AT=780.025n

.meas tran vdout0_0ck1580 FIND v(dout0_0) AT=795.025n

.meas tran vdout0_1ck1580 FIND v(dout0_1) AT=795.025n

.meas tran vdout0_2ck1580 FIND v(dout0_2) AT=795.025n

.meas tran vdout0_3ck1580 FIND v(dout0_3) AT=795.025n

.meas tran vdout0_4ck1580 FIND v(dout0_4) AT=795.025n

.meas tran vdout0_5ck1580 FIND v(dout0_5) AT=795.025n

.meas tran vdout0_6ck1580 FIND v(dout0_6) AT=795.025n

.meas tran vdout0_7ck1580 FIND v(dout0_7) AT=795.025n

.meas tran vdout0_8ck1580 FIND v(dout0_8) AT=795.025n

.meas tran vdout0_9ck1580 FIND v(dout0_9) AT=795.025n

.meas tran vdout0_10ck1580 FIND v(dout0_10) AT=795.025n

.meas tran vdout0_11ck1580 FIND v(dout0_11) AT=795.025n

.meas tran vdout0_12ck1580 FIND v(dout0_12) AT=795.025n

.meas tran vdout0_13ck1580 FIND v(dout0_13) AT=795.025n

.meas tran vdout0_14ck1580 FIND v(dout0_14) AT=795.025n

.meas tran vdout0_15ck1580 FIND v(dout0_15) AT=795.025n

.meas tran vdout0_16ck1580 FIND v(dout0_16) AT=795.025n

.meas tran vdout0_17ck1580 FIND v(dout0_17) AT=795.025n

.meas tran vdout0_18ck1580 FIND v(dout0_18) AT=795.025n

.meas tran vdout0_19ck1580 FIND v(dout0_19) AT=795.025n

.meas tran vdout0_20ck1580 FIND v(dout0_20) AT=795.025n

.meas tran vdout0_21ck1580 FIND v(dout0_21) AT=795.025n

.meas tran vdout0_22ck1580 FIND v(dout0_22) AT=795.025n

.meas tran vdout0_23ck1580 FIND v(dout0_23) AT=795.025n

.meas tran vdout0_24ck1580 FIND v(dout0_24) AT=795.025n

.meas tran vdout0_25ck1580 FIND v(dout0_25) AT=795.025n

.meas tran vdout0_26ck1580 FIND v(dout0_26) AT=795.025n

.meas tran vdout0_27ck1580 FIND v(dout0_27) AT=795.025n

.meas tran vdout0_28ck1580 FIND v(dout0_28) AT=795.025n

.meas tran vdout0_29ck1580 FIND v(dout0_29) AT=795.025n

.meas tran vdout0_30ck1580 FIND v(dout0_30) AT=795.025n

.meas tran vdout0_31ck1580 FIND v(dout0_31) AT=795.025n

.meas tran vdout0_0ck1590 FIND v(dout0_0) AT=800.025n

.meas tran vdout0_1ck1590 FIND v(dout0_1) AT=800.025n

.meas tran vdout0_2ck1590 FIND v(dout0_2) AT=800.025n

.meas tran vdout0_3ck1590 FIND v(dout0_3) AT=800.025n

.meas tran vdout0_4ck1590 FIND v(dout0_4) AT=800.025n

.meas tran vdout0_5ck1590 FIND v(dout0_5) AT=800.025n

.meas tran vdout0_6ck1590 FIND v(dout0_6) AT=800.025n

.meas tran vdout0_7ck1590 FIND v(dout0_7) AT=800.025n

.meas tran vdout0_8ck1590 FIND v(dout0_8) AT=800.025n

.meas tran vdout0_9ck1590 FIND v(dout0_9) AT=800.025n

.meas tran vdout0_10ck1590 FIND v(dout0_10) AT=800.025n

.meas tran vdout0_11ck1590 FIND v(dout0_11) AT=800.025n

.meas tran vdout0_12ck1590 FIND v(dout0_12) AT=800.025n

.meas tran vdout0_13ck1590 FIND v(dout0_13) AT=800.025n

.meas tran vdout0_14ck1590 FIND v(dout0_14) AT=800.025n

.meas tran vdout0_15ck1590 FIND v(dout0_15) AT=800.025n

.meas tran vdout0_16ck1590 FIND v(dout0_16) AT=800.025n

.meas tran vdout0_17ck1590 FIND v(dout0_17) AT=800.025n

.meas tran vdout0_18ck1590 FIND v(dout0_18) AT=800.025n

.meas tran vdout0_19ck1590 FIND v(dout0_19) AT=800.025n

.meas tran vdout0_20ck1590 FIND v(dout0_20) AT=800.025n

.meas tran vdout0_21ck1590 FIND v(dout0_21) AT=800.025n

.meas tran vdout0_22ck1590 FIND v(dout0_22) AT=800.025n

.meas tran vdout0_23ck1590 FIND v(dout0_23) AT=800.025n

.meas tran vdout0_24ck1590 FIND v(dout0_24) AT=800.025n

.meas tran vdout0_25ck1590 FIND v(dout0_25) AT=800.025n

.meas tran vdout0_26ck1590 FIND v(dout0_26) AT=800.025n

.meas tran vdout0_27ck1590 FIND v(dout0_27) AT=800.025n

.meas tran vdout0_28ck1590 FIND v(dout0_28) AT=800.025n

.meas tran vdout0_29ck1590 FIND v(dout0_29) AT=800.025n

.meas tran vdout0_30ck1590 FIND v(dout0_30) AT=800.025n

.meas tran vdout0_31ck1590 FIND v(dout0_31) AT=800.025n

.meas tran vdout0_0ck1600 FIND v(dout0_0) AT=805.025n

.meas tran vdout0_1ck1600 FIND v(dout0_1) AT=805.025n

.meas tran vdout0_2ck1600 FIND v(dout0_2) AT=805.025n

.meas tran vdout0_3ck1600 FIND v(dout0_3) AT=805.025n

.meas tran vdout0_4ck1600 FIND v(dout0_4) AT=805.025n

.meas tran vdout0_5ck1600 FIND v(dout0_5) AT=805.025n

.meas tran vdout0_6ck1600 FIND v(dout0_6) AT=805.025n

.meas tran vdout0_7ck1600 FIND v(dout0_7) AT=805.025n

.meas tran vdout0_8ck1600 FIND v(dout0_8) AT=805.025n

.meas tran vdout0_9ck1600 FIND v(dout0_9) AT=805.025n

.meas tran vdout0_10ck1600 FIND v(dout0_10) AT=805.025n

.meas tran vdout0_11ck1600 FIND v(dout0_11) AT=805.025n

.meas tran vdout0_12ck1600 FIND v(dout0_12) AT=805.025n

.meas tran vdout0_13ck1600 FIND v(dout0_13) AT=805.025n

.meas tran vdout0_14ck1600 FIND v(dout0_14) AT=805.025n

.meas tran vdout0_15ck1600 FIND v(dout0_15) AT=805.025n

.meas tran vdout0_16ck1600 FIND v(dout0_16) AT=805.025n

.meas tran vdout0_17ck1600 FIND v(dout0_17) AT=805.025n

.meas tran vdout0_18ck1600 FIND v(dout0_18) AT=805.025n

.meas tran vdout0_19ck1600 FIND v(dout0_19) AT=805.025n

.meas tran vdout0_20ck1600 FIND v(dout0_20) AT=805.025n

.meas tran vdout0_21ck1600 FIND v(dout0_21) AT=805.025n

.meas tran vdout0_22ck1600 FIND v(dout0_22) AT=805.025n

.meas tran vdout0_23ck1600 FIND v(dout0_23) AT=805.025n

.meas tran vdout0_24ck1600 FIND v(dout0_24) AT=805.025n

.meas tran vdout0_25ck1600 FIND v(dout0_25) AT=805.025n

.meas tran vdout0_26ck1600 FIND v(dout0_26) AT=805.025n

.meas tran vdout0_27ck1600 FIND v(dout0_27) AT=805.025n

.meas tran vdout0_28ck1600 FIND v(dout0_28) AT=805.025n

.meas tran vdout0_29ck1600 FIND v(dout0_29) AT=805.025n

.meas tran vdout0_30ck1600 FIND v(dout0_30) AT=805.025n

.meas tran vdout0_31ck1600 FIND v(dout0_31) AT=805.025n

.meas tran vdout0_0ck1620 FIND v(dout0_0) AT=815.025n

.meas tran vdout0_1ck1620 FIND v(dout0_1) AT=815.025n

.meas tran vdout0_2ck1620 FIND v(dout0_2) AT=815.025n

.meas tran vdout0_3ck1620 FIND v(dout0_3) AT=815.025n

.meas tran vdout0_4ck1620 FIND v(dout0_4) AT=815.025n

.meas tran vdout0_5ck1620 FIND v(dout0_5) AT=815.025n

.meas tran vdout0_6ck1620 FIND v(dout0_6) AT=815.025n

.meas tran vdout0_7ck1620 FIND v(dout0_7) AT=815.025n

.meas tran vdout0_8ck1620 FIND v(dout0_8) AT=815.025n

.meas tran vdout0_9ck1620 FIND v(dout0_9) AT=815.025n

.meas tran vdout0_10ck1620 FIND v(dout0_10) AT=815.025n

.meas tran vdout0_11ck1620 FIND v(dout0_11) AT=815.025n

.meas tran vdout0_12ck1620 FIND v(dout0_12) AT=815.025n

.meas tran vdout0_13ck1620 FIND v(dout0_13) AT=815.025n

.meas tran vdout0_14ck1620 FIND v(dout0_14) AT=815.025n

.meas tran vdout0_15ck1620 FIND v(dout0_15) AT=815.025n

.meas tran vdout0_16ck1620 FIND v(dout0_16) AT=815.025n

.meas tran vdout0_17ck1620 FIND v(dout0_17) AT=815.025n

.meas tran vdout0_18ck1620 FIND v(dout0_18) AT=815.025n

.meas tran vdout0_19ck1620 FIND v(dout0_19) AT=815.025n

.meas tran vdout0_20ck1620 FIND v(dout0_20) AT=815.025n

.meas tran vdout0_21ck1620 FIND v(dout0_21) AT=815.025n

.meas tran vdout0_22ck1620 FIND v(dout0_22) AT=815.025n

.meas tran vdout0_23ck1620 FIND v(dout0_23) AT=815.025n

.meas tran vdout0_24ck1620 FIND v(dout0_24) AT=815.025n

.meas tran vdout0_25ck1620 FIND v(dout0_25) AT=815.025n

.meas tran vdout0_26ck1620 FIND v(dout0_26) AT=815.025n

.meas tran vdout0_27ck1620 FIND v(dout0_27) AT=815.025n

.meas tran vdout0_28ck1620 FIND v(dout0_28) AT=815.025n

.meas tran vdout0_29ck1620 FIND v(dout0_29) AT=815.025n

.meas tran vdout0_30ck1620 FIND v(dout0_30) AT=815.025n

.meas tran vdout0_31ck1620 FIND v(dout0_31) AT=815.025n

.meas tran vdout0_0ck1660 FIND v(dout0_0) AT=835.025n

.meas tran vdout0_1ck1660 FIND v(dout0_1) AT=835.025n

.meas tran vdout0_2ck1660 FIND v(dout0_2) AT=835.025n

.meas tran vdout0_3ck1660 FIND v(dout0_3) AT=835.025n

.meas tran vdout0_4ck1660 FIND v(dout0_4) AT=835.025n

.meas tran vdout0_5ck1660 FIND v(dout0_5) AT=835.025n

.meas tran vdout0_6ck1660 FIND v(dout0_6) AT=835.025n

.meas tran vdout0_7ck1660 FIND v(dout0_7) AT=835.025n

.meas tran vdout0_8ck1660 FIND v(dout0_8) AT=835.025n

.meas tran vdout0_9ck1660 FIND v(dout0_9) AT=835.025n

.meas tran vdout0_10ck1660 FIND v(dout0_10) AT=835.025n

.meas tran vdout0_11ck1660 FIND v(dout0_11) AT=835.025n

.meas tran vdout0_12ck1660 FIND v(dout0_12) AT=835.025n

.meas tran vdout0_13ck1660 FIND v(dout0_13) AT=835.025n

.meas tran vdout0_14ck1660 FIND v(dout0_14) AT=835.025n

.meas tran vdout0_15ck1660 FIND v(dout0_15) AT=835.025n

.meas tran vdout0_16ck1660 FIND v(dout0_16) AT=835.025n

.meas tran vdout0_17ck1660 FIND v(dout0_17) AT=835.025n

.meas tran vdout0_18ck1660 FIND v(dout0_18) AT=835.025n

.meas tran vdout0_19ck1660 FIND v(dout0_19) AT=835.025n

.meas tran vdout0_20ck1660 FIND v(dout0_20) AT=835.025n

.meas tran vdout0_21ck1660 FIND v(dout0_21) AT=835.025n

.meas tran vdout0_22ck1660 FIND v(dout0_22) AT=835.025n

.meas tran vdout0_23ck1660 FIND v(dout0_23) AT=835.025n

.meas tran vdout0_24ck1660 FIND v(dout0_24) AT=835.025n

.meas tran vdout0_25ck1660 FIND v(dout0_25) AT=835.025n

.meas tran vdout0_26ck1660 FIND v(dout0_26) AT=835.025n

.meas tran vdout0_27ck1660 FIND v(dout0_27) AT=835.025n

.meas tran vdout0_28ck1660 FIND v(dout0_28) AT=835.025n

.meas tran vdout0_29ck1660 FIND v(dout0_29) AT=835.025n

.meas tran vdout0_30ck1660 FIND v(dout0_30) AT=835.025n

.meas tran vdout0_31ck1660 FIND v(dout0_31) AT=835.025n

.meas tran vdout0_0ck1680 FIND v(dout0_0) AT=845.025n

.meas tran vdout0_1ck1680 FIND v(dout0_1) AT=845.025n

.meas tran vdout0_2ck1680 FIND v(dout0_2) AT=845.025n

.meas tran vdout0_3ck1680 FIND v(dout0_3) AT=845.025n

.meas tran vdout0_4ck1680 FIND v(dout0_4) AT=845.025n

.meas tran vdout0_5ck1680 FIND v(dout0_5) AT=845.025n

.meas tran vdout0_6ck1680 FIND v(dout0_6) AT=845.025n

.meas tran vdout0_7ck1680 FIND v(dout0_7) AT=845.025n

.meas tran vdout0_8ck1680 FIND v(dout0_8) AT=845.025n

.meas tran vdout0_9ck1680 FIND v(dout0_9) AT=845.025n

.meas tran vdout0_10ck1680 FIND v(dout0_10) AT=845.025n

.meas tran vdout0_11ck1680 FIND v(dout0_11) AT=845.025n

.meas tran vdout0_12ck1680 FIND v(dout0_12) AT=845.025n

.meas tran vdout0_13ck1680 FIND v(dout0_13) AT=845.025n

.meas tran vdout0_14ck1680 FIND v(dout0_14) AT=845.025n

.meas tran vdout0_15ck1680 FIND v(dout0_15) AT=845.025n

.meas tran vdout0_16ck1680 FIND v(dout0_16) AT=845.025n

.meas tran vdout0_17ck1680 FIND v(dout0_17) AT=845.025n

.meas tran vdout0_18ck1680 FIND v(dout0_18) AT=845.025n

.meas tran vdout0_19ck1680 FIND v(dout0_19) AT=845.025n

.meas tran vdout0_20ck1680 FIND v(dout0_20) AT=845.025n

.meas tran vdout0_21ck1680 FIND v(dout0_21) AT=845.025n

.meas tran vdout0_22ck1680 FIND v(dout0_22) AT=845.025n

.meas tran vdout0_23ck1680 FIND v(dout0_23) AT=845.025n

.meas tran vdout0_24ck1680 FIND v(dout0_24) AT=845.025n

.meas tran vdout0_25ck1680 FIND v(dout0_25) AT=845.025n

.meas tran vdout0_26ck1680 FIND v(dout0_26) AT=845.025n

.meas tran vdout0_27ck1680 FIND v(dout0_27) AT=845.025n

.meas tran vdout0_28ck1680 FIND v(dout0_28) AT=845.025n

.meas tran vdout0_29ck1680 FIND v(dout0_29) AT=845.025n

.meas tran vdout0_30ck1680 FIND v(dout0_30) AT=845.025n

.meas tran vdout0_31ck1680 FIND v(dout0_31) AT=845.025n

.meas tran vdout0_0ck1690 FIND v(dout0_0) AT=850.025n

.meas tran vdout0_1ck1690 FIND v(dout0_1) AT=850.025n

.meas tran vdout0_2ck1690 FIND v(dout0_2) AT=850.025n

.meas tran vdout0_3ck1690 FIND v(dout0_3) AT=850.025n

.meas tran vdout0_4ck1690 FIND v(dout0_4) AT=850.025n

.meas tran vdout0_5ck1690 FIND v(dout0_5) AT=850.025n

.meas tran vdout0_6ck1690 FIND v(dout0_6) AT=850.025n

.meas tran vdout0_7ck1690 FIND v(dout0_7) AT=850.025n

.meas tran vdout0_8ck1690 FIND v(dout0_8) AT=850.025n

.meas tran vdout0_9ck1690 FIND v(dout0_9) AT=850.025n

.meas tran vdout0_10ck1690 FIND v(dout0_10) AT=850.025n

.meas tran vdout0_11ck1690 FIND v(dout0_11) AT=850.025n

.meas tran vdout0_12ck1690 FIND v(dout0_12) AT=850.025n

.meas tran vdout0_13ck1690 FIND v(dout0_13) AT=850.025n

.meas tran vdout0_14ck1690 FIND v(dout0_14) AT=850.025n

.meas tran vdout0_15ck1690 FIND v(dout0_15) AT=850.025n

.meas tran vdout0_16ck1690 FIND v(dout0_16) AT=850.025n

.meas tran vdout0_17ck1690 FIND v(dout0_17) AT=850.025n

.meas tran vdout0_18ck1690 FIND v(dout0_18) AT=850.025n

.meas tran vdout0_19ck1690 FIND v(dout0_19) AT=850.025n

.meas tran vdout0_20ck1690 FIND v(dout0_20) AT=850.025n

.meas tran vdout0_21ck1690 FIND v(dout0_21) AT=850.025n

.meas tran vdout0_22ck1690 FIND v(dout0_22) AT=850.025n

.meas tran vdout0_23ck1690 FIND v(dout0_23) AT=850.025n

.meas tran vdout0_24ck1690 FIND v(dout0_24) AT=850.025n

.meas tran vdout0_25ck1690 FIND v(dout0_25) AT=850.025n

.meas tran vdout0_26ck1690 FIND v(dout0_26) AT=850.025n

.meas tran vdout0_27ck1690 FIND v(dout0_27) AT=850.025n

.meas tran vdout0_28ck1690 FIND v(dout0_28) AT=850.025n

.meas tran vdout0_29ck1690 FIND v(dout0_29) AT=850.025n

.meas tran vdout0_30ck1690 FIND v(dout0_30) AT=850.025n

.meas tran vdout0_31ck1690 FIND v(dout0_31) AT=850.025n

.meas tran vdout0_0ck1720 FIND v(dout0_0) AT=865.025n

.meas tran vdout0_1ck1720 FIND v(dout0_1) AT=865.025n

.meas tran vdout0_2ck1720 FIND v(dout0_2) AT=865.025n

.meas tran vdout0_3ck1720 FIND v(dout0_3) AT=865.025n

.meas tran vdout0_4ck1720 FIND v(dout0_4) AT=865.025n

.meas tran vdout0_5ck1720 FIND v(dout0_5) AT=865.025n

.meas tran vdout0_6ck1720 FIND v(dout0_6) AT=865.025n

.meas tran vdout0_7ck1720 FIND v(dout0_7) AT=865.025n

.meas tran vdout0_8ck1720 FIND v(dout0_8) AT=865.025n

.meas tran vdout0_9ck1720 FIND v(dout0_9) AT=865.025n

.meas tran vdout0_10ck1720 FIND v(dout0_10) AT=865.025n

.meas tran vdout0_11ck1720 FIND v(dout0_11) AT=865.025n

.meas tran vdout0_12ck1720 FIND v(dout0_12) AT=865.025n

.meas tran vdout0_13ck1720 FIND v(dout0_13) AT=865.025n

.meas tran vdout0_14ck1720 FIND v(dout0_14) AT=865.025n

.meas tran vdout0_15ck1720 FIND v(dout0_15) AT=865.025n

.meas tran vdout0_16ck1720 FIND v(dout0_16) AT=865.025n

.meas tran vdout0_17ck1720 FIND v(dout0_17) AT=865.025n

.meas tran vdout0_18ck1720 FIND v(dout0_18) AT=865.025n

.meas tran vdout0_19ck1720 FIND v(dout0_19) AT=865.025n

.meas tran vdout0_20ck1720 FIND v(dout0_20) AT=865.025n

.meas tran vdout0_21ck1720 FIND v(dout0_21) AT=865.025n

.meas tran vdout0_22ck1720 FIND v(dout0_22) AT=865.025n

.meas tran vdout0_23ck1720 FIND v(dout0_23) AT=865.025n

.meas tran vdout0_24ck1720 FIND v(dout0_24) AT=865.025n

.meas tran vdout0_25ck1720 FIND v(dout0_25) AT=865.025n

.meas tran vdout0_26ck1720 FIND v(dout0_26) AT=865.025n

.meas tran vdout0_27ck1720 FIND v(dout0_27) AT=865.025n

.meas tran vdout0_28ck1720 FIND v(dout0_28) AT=865.025n

.meas tran vdout0_29ck1720 FIND v(dout0_29) AT=865.025n

.meas tran vdout0_30ck1720 FIND v(dout0_30) AT=865.025n

.meas tran vdout0_31ck1720 FIND v(dout0_31) AT=865.025n

.meas tran vdout0_0ck1730 FIND v(dout0_0) AT=870.025n

.meas tran vdout0_1ck1730 FIND v(dout0_1) AT=870.025n

.meas tran vdout0_2ck1730 FIND v(dout0_2) AT=870.025n

.meas tran vdout0_3ck1730 FIND v(dout0_3) AT=870.025n

.meas tran vdout0_4ck1730 FIND v(dout0_4) AT=870.025n

.meas tran vdout0_5ck1730 FIND v(dout0_5) AT=870.025n

.meas tran vdout0_6ck1730 FIND v(dout0_6) AT=870.025n

.meas tran vdout0_7ck1730 FIND v(dout0_7) AT=870.025n

.meas tran vdout0_8ck1730 FIND v(dout0_8) AT=870.025n

.meas tran vdout0_9ck1730 FIND v(dout0_9) AT=870.025n

.meas tran vdout0_10ck1730 FIND v(dout0_10) AT=870.025n

.meas tran vdout0_11ck1730 FIND v(dout0_11) AT=870.025n

.meas tran vdout0_12ck1730 FIND v(dout0_12) AT=870.025n

.meas tran vdout0_13ck1730 FIND v(dout0_13) AT=870.025n

.meas tran vdout0_14ck1730 FIND v(dout0_14) AT=870.025n

.meas tran vdout0_15ck1730 FIND v(dout0_15) AT=870.025n

.meas tran vdout0_16ck1730 FIND v(dout0_16) AT=870.025n

.meas tran vdout0_17ck1730 FIND v(dout0_17) AT=870.025n

.meas tran vdout0_18ck1730 FIND v(dout0_18) AT=870.025n

.meas tran vdout0_19ck1730 FIND v(dout0_19) AT=870.025n

.meas tran vdout0_20ck1730 FIND v(dout0_20) AT=870.025n

.meas tran vdout0_21ck1730 FIND v(dout0_21) AT=870.025n

.meas tran vdout0_22ck1730 FIND v(dout0_22) AT=870.025n

.meas tran vdout0_23ck1730 FIND v(dout0_23) AT=870.025n

.meas tran vdout0_24ck1730 FIND v(dout0_24) AT=870.025n

.meas tran vdout0_25ck1730 FIND v(dout0_25) AT=870.025n

.meas tran vdout0_26ck1730 FIND v(dout0_26) AT=870.025n

.meas tran vdout0_27ck1730 FIND v(dout0_27) AT=870.025n

.meas tran vdout0_28ck1730 FIND v(dout0_28) AT=870.025n

.meas tran vdout0_29ck1730 FIND v(dout0_29) AT=870.025n

.meas tran vdout0_30ck1730 FIND v(dout0_30) AT=870.025n

.meas tran vdout0_31ck1730 FIND v(dout0_31) AT=870.025n

.meas tran vdout0_0ck1740 FIND v(dout0_0) AT=875.025n

.meas tran vdout0_1ck1740 FIND v(dout0_1) AT=875.025n

.meas tran vdout0_2ck1740 FIND v(dout0_2) AT=875.025n

.meas tran vdout0_3ck1740 FIND v(dout0_3) AT=875.025n

.meas tran vdout0_4ck1740 FIND v(dout0_4) AT=875.025n

.meas tran vdout0_5ck1740 FIND v(dout0_5) AT=875.025n

.meas tran vdout0_6ck1740 FIND v(dout0_6) AT=875.025n

.meas tran vdout0_7ck1740 FIND v(dout0_7) AT=875.025n

.meas tran vdout0_8ck1740 FIND v(dout0_8) AT=875.025n

.meas tran vdout0_9ck1740 FIND v(dout0_9) AT=875.025n

.meas tran vdout0_10ck1740 FIND v(dout0_10) AT=875.025n

.meas tran vdout0_11ck1740 FIND v(dout0_11) AT=875.025n

.meas tran vdout0_12ck1740 FIND v(dout0_12) AT=875.025n

.meas tran vdout0_13ck1740 FIND v(dout0_13) AT=875.025n

.meas tran vdout0_14ck1740 FIND v(dout0_14) AT=875.025n

.meas tran vdout0_15ck1740 FIND v(dout0_15) AT=875.025n

.meas tran vdout0_16ck1740 FIND v(dout0_16) AT=875.025n

.meas tran vdout0_17ck1740 FIND v(dout0_17) AT=875.025n

.meas tran vdout0_18ck1740 FIND v(dout0_18) AT=875.025n

.meas tran vdout0_19ck1740 FIND v(dout0_19) AT=875.025n

.meas tran vdout0_20ck1740 FIND v(dout0_20) AT=875.025n

.meas tran vdout0_21ck1740 FIND v(dout0_21) AT=875.025n

.meas tran vdout0_22ck1740 FIND v(dout0_22) AT=875.025n

.meas tran vdout0_23ck1740 FIND v(dout0_23) AT=875.025n

.meas tran vdout0_24ck1740 FIND v(dout0_24) AT=875.025n

.meas tran vdout0_25ck1740 FIND v(dout0_25) AT=875.025n

.meas tran vdout0_26ck1740 FIND v(dout0_26) AT=875.025n

.meas tran vdout0_27ck1740 FIND v(dout0_27) AT=875.025n

.meas tran vdout0_28ck1740 FIND v(dout0_28) AT=875.025n

.meas tran vdout0_29ck1740 FIND v(dout0_29) AT=875.025n

.meas tran vdout0_30ck1740 FIND v(dout0_30) AT=875.025n

.meas tran vdout0_31ck1740 FIND v(dout0_31) AT=875.025n

.meas tran vdout0_0ck1760 FIND v(dout0_0) AT=885.025n

.meas tran vdout0_1ck1760 FIND v(dout0_1) AT=885.025n

.meas tran vdout0_2ck1760 FIND v(dout0_2) AT=885.025n

.meas tran vdout0_3ck1760 FIND v(dout0_3) AT=885.025n

.meas tran vdout0_4ck1760 FIND v(dout0_4) AT=885.025n

.meas tran vdout0_5ck1760 FIND v(dout0_5) AT=885.025n

.meas tran vdout0_6ck1760 FIND v(dout0_6) AT=885.025n

.meas tran vdout0_7ck1760 FIND v(dout0_7) AT=885.025n

.meas tran vdout0_8ck1760 FIND v(dout0_8) AT=885.025n

.meas tran vdout0_9ck1760 FIND v(dout0_9) AT=885.025n

.meas tran vdout0_10ck1760 FIND v(dout0_10) AT=885.025n

.meas tran vdout0_11ck1760 FIND v(dout0_11) AT=885.025n

.meas tran vdout0_12ck1760 FIND v(dout0_12) AT=885.025n

.meas tran vdout0_13ck1760 FIND v(dout0_13) AT=885.025n

.meas tran vdout0_14ck1760 FIND v(dout0_14) AT=885.025n

.meas tran vdout0_15ck1760 FIND v(dout0_15) AT=885.025n

.meas tran vdout0_16ck1760 FIND v(dout0_16) AT=885.025n

.meas tran vdout0_17ck1760 FIND v(dout0_17) AT=885.025n

.meas tran vdout0_18ck1760 FIND v(dout0_18) AT=885.025n

.meas tran vdout0_19ck1760 FIND v(dout0_19) AT=885.025n

.meas tran vdout0_20ck1760 FIND v(dout0_20) AT=885.025n

.meas tran vdout0_21ck1760 FIND v(dout0_21) AT=885.025n

.meas tran vdout0_22ck1760 FIND v(dout0_22) AT=885.025n

.meas tran vdout0_23ck1760 FIND v(dout0_23) AT=885.025n

.meas tran vdout0_24ck1760 FIND v(dout0_24) AT=885.025n

.meas tran vdout0_25ck1760 FIND v(dout0_25) AT=885.025n

.meas tran vdout0_26ck1760 FIND v(dout0_26) AT=885.025n

.meas tran vdout0_27ck1760 FIND v(dout0_27) AT=885.025n

.meas tran vdout0_28ck1760 FIND v(dout0_28) AT=885.025n

.meas tran vdout0_29ck1760 FIND v(dout0_29) AT=885.025n

.meas tran vdout0_30ck1760 FIND v(dout0_30) AT=885.025n

.meas tran vdout0_31ck1760 FIND v(dout0_31) AT=885.025n

.meas tran vdout0_0ck1780 FIND v(dout0_0) AT=895.025n

.meas tran vdout0_1ck1780 FIND v(dout0_1) AT=895.025n

.meas tran vdout0_2ck1780 FIND v(dout0_2) AT=895.025n

.meas tran vdout0_3ck1780 FIND v(dout0_3) AT=895.025n

.meas tran vdout0_4ck1780 FIND v(dout0_4) AT=895.025n

.meas tran vdout0_5ck1780 FIND v(dout0_5) AT=895.025n

.meas tran vdout0_6ck1780 FIND v(dout0_6) AT=895.025n

.meas tran vdout0_7ck1780 FIND v(dout0_7) AT=895.025n

.meas tran vdout0_8ck1780 FIND v(dout0_8) AT=895.025n

.meas tran vdout0_9ck1780 FIND v(dout0_9) AT=895.025n

.meas tran vdout0_10ck1780 FIND v(dout0_10) AT=895.025n

.meas tran vdout0_11ck1780 FIND v(dout0_11) AT=895.025n

.meas tran vdout0_12ck1780 FIND v(dout0_12) AT=895.025n

.meas tran vdout0_13ck1780 FIND v(dout0_13) AT=895.025n

.meas tran vdout0_14ck1780 FIND v(dout0_14) AT=895.025n

.meas tran vdout0_15ck1780 FIND v(dout0_15) AT=895.025n

.meas tran vdout0_16ck1780 FIND v(dout0_16) AT=895.025n

.meas tran vdout0_17ck1780 FIND v(dout0_17) AT=895.025n

.meas tran vdout0_18ck1780 FIND v(dout0_18) AT=895.025n

.meas tran vdout0_19ck1780 FIND v(dout0_19) AT=895.025n

.meas tran vdout0_20ck1780 FIND v(dout0_20) AT=895.025n

.meas tran vdout0_21ck1780 FIND v(dout0_21) AT=895.025n

.meas tran vdout0_22ck1780 FIND v(dout0_22) AT=895.025n

.meas tran vdout0_23ck1780 FIND v(dout0_23) AT=895.025n

.meas tran vdout0_24ck1780 FIND v(dout0_24) AT=895.025n

.meas tran vdout0_25ck1780 FIND v(dout0_25) AT=895.025n

.meas tran vdout0_26ck1780 FIND v(dout0_26) AT=895.025n

.meas tran vdout0_27ck1780 FIND v(dout0_27) AT=895.025n

.meas tran vdout0_28ck1780 FIND v(dout0_28) AT=895.025n

.meas tran vdout0_29ck1780 FIND v(dout0_29) AT=895.025n

.meas tran vdout0_30ck1780 FIND v(dout0_30) AT=895.025n

.meas tran vdout0_31ck1780 FIND v(dout0_31) AT=895.025n

.meas tran vdout0_0ck1800 FIND v(dout0_0) AT=905.025n

.meas tran vdout0_1ck1800 FIND v(dout0_1) AT=905.025n

.meas tran vdout0_2ck1800 FIND v(dout0_2) AT=905.025n

.meas tran vdout0_3ck1800 FIND v(dout0_3) AT=905.025n

.meas tran vdout0_4ck1800 FIND v(dout0_4) AT=905.025n

.meas tran vdout0_5ck1800 FIND v(dout0_5) AT=905.025n

.meas tran vdout0_6ck1800 FIND v(dout0_6) AT=905.025n

.meas tran vdout0_7ck1800 FIND v(dout0_7) AT=905.025n

.meas tran vdout0_8ck1800 FIND v(dout0_8) AT=905.025n

.meas tran vdout0_9ck1800 FIND v(dout0_9) AT=905.025n

.meas tran vdout0_10ck1800 FIND v(dout0_10) AT=905.025n

.meas tran vdout0_11ck1800 FIND v(dout0_11) AT=905.025n

.meas tran vdout0_12ck1800 FIND v(dout0_12) AT=905.025n

.meas tran vdout0_13ck1800 FIND v(dout0_13) AT=905.025n

.meas tran vdout0_14ck1800 FIND v(dout0_14) AT=905.025n

.meas tran vdout0_15ck1800 FIND v(dout0_15) AT=905.025n

.meas tran vdout0_16ck1800 FIND v(dout0_16) AT=905.025n

.meas tran vdout0_17ck1800 FIND v(dout0_17) AT=905.025n

.meas tran vdout0_18ck1800 FIND v(dout0_18) AT=905.025n

.meas tran vdout0_19ck1800 FIND v(dout0_19) AT=905.025n

.meas tran vdout0_20ck1800 FIND v(dout0_20) AT=905.025n

.meas tran vdout0_21ck1800 FIND v(dout0_21) AT=905.025n

.meas tran vdout0_22ck1800 FIND v(dout0_22) AT=905.025n

.meas tran vdout0_23ck1800 FIND v(dout0_23) AT=905.025n

.meas tran vdout0_24ck1800 FIND v(dout0_24) AT=905.025n

.meas tran vdout0_25ck1800 FIND v(dout0_25) AT=905.025n

.meas tran vdout0_26ck1800 FIND v(dout0_26) AT=905.025n

.meas tran vdout0_27ck1800 FIND v(dout0_27) AT=905.025n

.meas tran vdout0_28ck1800 FIND v(dout0_28) AT=905.025n

.meas tran vdout0_29ck1800 FIND v(dout0_29) AT=905.025n

.meas tran vdout0_30ck1800 FIND v(dout0_30) AT=905.025n

.meas tran vdout0_31ck1800 FIND v(dout0_31) AT=905.025n

.meas tran vdout0_0ck1840 FIND v(dout0_0) AT=925.025n

.meas tran vdout0_1ck1840 FIND v(dout0_1) AT=925.025n

.meas tran vdout0_2ck1840 FIND v(dout0_2) AT=925.025n

.meas tran vdout0_3ck1840 FIND v(dout0_3) AT=925.025n

.meas tran vdout0_4ck1840 FIND v(dout0_4) AT=925.025n

.meas tran vdout0_5ck1840 FIND v(dout0_5) AT=925.025n

.meas tran vdout0_6ck1840 FIND v(dout0_6) AT=925.025n

.meas tran vdout0_7ck1840 FIND v(dout0_7) AT=925.025n

.meas tran vdout0_8ck1840 FIND v(dout0_8) AT=925.025n

.meas tran vdout0_9ck1840 FIND v(dout0_9) AT=925.025n

.meas tran vdout0_10ck1840 FIND v(dout0_10) AT=925.025n

.meas tran vdout0_11ck1840 FIND v(dout0_11) AT=925.025n

.meas tran vdout0_12ck1840 FIND v(dout0_12) AT=925.025n

.meas tran vdout0_13ck1840 FIND v(dout0_13) AT=925.025n

.meas tran vdout0_14ck1840 FIND v(dout0_14) AT=925.025n

.meas tran vdout0_15ck1840 FIND v(dout0_15) AT=925.025n

.meas tran vdout0_16ck1840 FIND v(dout0_16) AT=925.025n

.meas tran vdout0_17ck1840 FIND v(dout0_17) AT=925.025n

.meas tran vdout0_18ck1840 FIND v(dout0_18) AT=925.025n

.meas tran vdout0_19ck1840 FIND v(dout0_19) AT=925.025n

.meas tran vdout0_20ck1840 FIND v(dout0_20) AT=925.025n

.meas tran vdout0_21ck1840 FIND v(dout0_21) AT=925.025n

.meas tran vdout0_22ck1840 FIND v(dout0_22) AT=925.025n

.meas tran vdout0_23ck1840 FIND v(dout0_23) AT=925.025n

.meas tran vdout0_24ck1840 FIND v(dout0_24) AT=925.025n

.meas tran vdout0_25ck1840 FIND v(dout0_25) AT=925.025n

.meas tran vdout0_26ck1840 FIND v(dout0_26) AT=925.025n

.meas tran vdout0_27ck1840 FIND v(dout0_27) AT=925.025n

.meas tran vdout0_28ck1840 FIND v(dout0_28) AT=925.025n

.meas tran vdout0_29ck1840 FIND v(dout0_29) AT=925.025n

.meas tran vdout0_30ck1840 FIND v(dout0_30) AT=925.025n

.meas tran vdout0_31ck1840 FIND v(dout0_31) AT=925.025n

.meas tran vdout0_0ck1860 FIND v(dout0_0) AT=935.025n

.meas tran vdout0_1ck1860 FIND v(dout0_1) AT=935.025n

.meas tran vdout0_2ck1860 FIND v(dout0_2) AT=935.025n

.meas tran vdout0_3ck1860 FIND v(dout0_3) AT=935.025n

.meas tran vdout0_4ck1860 FIND v(dout0_4) AT=935.025n

.meas tran vdout0_5ck1860 FIND v(dout0_5) AT=935.025n

.meas tran vdout0_6ck1860 FIND v(dout0_6) AT=935.025n

.meas tran vdout0_7ck1860 FIND v(dout0_7) AT=935.025n

.meas tran vdout0_8ck1860 FIND v(dout0_8) AT=935.025n

.meas tran vdout0_9ck1860 FIND v(dout0_9) AT=935.025n

.meas tran vdout0_10ck1860 FIND v(dout0_10) AT=935.025n

.meas tran vdout0_11ck1860 FIND v(dout0_11) AT=935.025n

.meas tran vdout0_12ck1860 FIND v(dout0_12) AT=935.025n

.meas tran vdout0_13ck1860 FIND v(dout0_13) AT=935.025n

.meas tran vdout0_14ck1860 FIND v(dout0_14) AT=935.025n

.meas tran vdout0_15ck1860 FIND v(dout0_15) AT=935.025n

.meas tran vdout0_16ck1860 FIND v(dout0_16) AT=935.025n

.meas tran vdout0_17ck1860 FIND v(dout0_17) AT=935.025n

.meas tran vdout0_18ck1860 FIND v(dout0_18) AT=935.025n

.meas tran vdout0_19ck1860 FIND v(dout0_19) AT=935.025n

.meas tran vdout0_20ck1860 FIND v(dout0_20) AT=935.025n

.meas tran vdout0_21ck1860 FIND v(dout0_21) AT=935.025n

.meas tran vdout0_22ck1860 FIND v(dout0_22) AT=935.025n

.meas tran vdout0_23ck1860 FIND v(dout0_23) AT=935.025n

.meas tran vdout0_24ck1860 FIND v(dout0_24) AT=935.025n

.meas tran vdout0_25ck1860 FIND v(dout0_25) AT=935.025n

.meas tran vdout0_26ck1860 FIND v(dout0_26) AT=935.025n

.meas tran vdout0_27ck1860 FIND v(dout0_27) AT=935.025n

.meas tran vdout0_28ck1860 FIND v(dout0_28) AT=935.025n

.meas tran vdout0_29ck1860 FIND v(dout0_29) AT=935.025n

.meas tran vdout0_30ck1860 FIND v(dout0_30) AT=935.025n

.meas tran vdout0_31ck1860 FIND v(dout0_31) AT=935.025n

.meas tran vdout0_0ck1900 FIND v(dout0_0) AT=955.025n

.meas tran vdout0_1ck1900 FIND v(dout0_1) AT=955.025n

.meas tran vdout0_2ck1900 FIND v(dout0_2) AT=955.025n

.meas tran vdout0_3ck1900 FIND v(dout0_3) AT=955.025n

.meas tran vdout0_4ck1900 FIND v(dout0_4) AT=955.025n

.meas tran vdout0_5ck1900 FIND v(dout0_5) AT=955.025n

.meas tran vdout0_6ck1900 FIND v(dout0_6) AT=955.025n

.meas tran vdout0_7ck1900 FIND v(dout0_7) AT=955.025n

.meas tran vdout0_8ck1900 FIND v(dout0_8) AT=955.025n

.meas tran vdout0_9ck1900 FIND v(dout0_9) AT=955.025n

.meas tran vdout0_10ck1900 FIND v(dout0_10) AT=955.025n

.meas tran vdout0_11ck1900 FIND v(dout0_11) AT=955.025n

.meas tran vdout0_12ck1900 FIND v(dout0_12) AT=955.025n

.meas tran vdout0_13ck1900 FIND v(dout0_13) AT=955.025n

.meas tran vdout0_14ck1900 FIND v(dout0_14) AT=955.025n

.meas tran vdout0_15ck1900 FIND v(dout0_15) AT=955.025n

.meas tran vdout0_16ck1900 FIND v(dout0_16) AT=955.025n

.meas tran vdout0_17ck1900 FIND v(dout0_17) AT=955.025n

.meas tran vdout0_18ck1900 FIND v(dout0_18) AT=955.025n

.meas tran vdout0_19ck1900 FIND v(dout0_19) AT=955.025n

.meas tran vdout0_20ck1900 FIND v(dout0_20) AT=955.025n

.meas tran vdout0_21ck1900 FIND v(dout0_21) AT=955.025n

.meas tran vdout0_22ck1900 FIND v(dout0_22) AT=955.025n

.meas tran vdout0_23ck1900 FIND v(dout0_23) AT=955.025n

.meas tran vdout0_24ck1900 FIND v(dout0_24) AT=955.025n

.meas tran vdout0_25ck1900 FIND v(dout0_25) AT=955.025n

.meas tran vdout0_26ck1900 FIND v(dout0_26) AT=955.025n

.meas tran vdout0_27ck1900 FIND v(dout0_27) AT=955.025n

.meas tran vdout0_28ck1900 FIND v(dout0_28) AT=955.025n

.meas tran vdout0_29ck1900 FIND v(dout0_29) AT=955.025n

.meas tran vdout0_30ck1900 FIND v(dout0_30) AT=955.025n

.meas tran vdout0_31ck1900 FIND v(dout0_31) AT=955.025n

.meas tran vdout0_0ck1910 FIND v(dout0_0) AT=960.025n

.meas tran vdout0_1ck1910 FIND v(dout0_1) AT=960.025n

.meas tran vdout0_2ck1910 FIND v(dout0_2) AT=960.025n

.meas tran vdout0_3ck1910 FIND v(dout0_3) AT=960.025n

.meas tran vdout0_4ck1910 FIND v(dout0_4) AT=960.025n

.meas tran vdout0_5ck1910 FIND v(dout0_5) AT=960.025n

.meas tran vdout0_6ck1910 FIND v(dout0_6) AT=960.025n

.meas tran vdout0_7ck1910 FIND v(dout0_7) AT=960.025n

.meas tran vdout0_8ck1910 FIND v(dout0_8) AT=960.025n

.meas tran vdout0_9ck1910 FIND v(dout0_9) AT=960.025n

.meas tran vdout0_10ck1910 FIND v(dout0_10) AT=960.025n

.meas tran vdout0_11ck1910 FIND v(dout0_11) AT=960.025n

.meas tran vdout0_12ck1910 FIND v(dout0_12) AT=960.025n

.meas tran vdout0_13ck1910 FIND v(dout0_13) AT=960.025n

.meas tran vdout0_14ck1910 FIND v(dout0_14) AT=960.025n

.meas tran vdout0_15ck1910 FIND v(dout0_15) AT=960.025n

.meas tran vdout0_16ck1910 FIND v(dout0_16) AT=960.025n

.meas tran vdout0_17ck1910 FIND v(dout0_17) AT=960.025n

.meas tran vdout0_18ck1910 FIND v(dout0_18) AT=960.025n

.meas tran vdout0_19ck1910 FIND v(dout0_19) AT=960.025n

.meas tran vdout0_20ck1910 FIND v(dout0_20) AT=960.025n

.meas tran vdout0_21ck1910 FIND v(dout0_21) AT=960.025n

.meas tran vdout0_22ck1910 FIND v(dout0_22) AT=960.025n

.meas tran vdout0_23ck1910 FIND v(dout0_23) AT=960.025n

.meas tran vdout0_24ck1910 FIND v(dout0_24) AT=960.025n

.meas tran vdout0_25ck1910 FIND v(dout0_25) AT=960.025n

.meas tran vdout0_26ck1910 FIND v(dout0_26) AT=960.025n

.meas tran vdout0_27ck1910 FIND v(dout0_27) AT=960.025n

.meas tran vdout0_28ck1910 FIND v(dout0_28) AT=960.025n

.meas tran vdout0_29ck1910 FIND v(dout0_29) AT=960.025n

.meas tran vdout0_30ck1910 FIND v(dout0_30) AT=960.025n

.meas tran vdout0_31ck1910 FIND v(dout0_31) AT=960.025n

.meas tran vdout0_0ck1920 FIND v(dout0_0) AT=965.025n

.meas tran vdout0_1ck1920 FIND v(dout0_1) AT=965.025n

.meas tran vdout0_2ck1920 FIND v(dout0_2) AT=965.025n

.meas tran vdout0_3ck1920 FIND v(dout0_3) AT=965.025n

.meas tran vdout0_4ck1920 FIND v(dout0_4) AT=965.025n

.meas tran vdout0_5ck1920 FIND v(dout0_5) AT=965.025n

.meas tran vdout0_6ck1920 FIND v(dout0_6) AT=965.025n

.meas tran vdout0_7ck1920 FIND v(dout0_7) AT=965.025n

.meas tran vdout0_8ck1920 FIND v(dout0_8) AT=965.025n

.meas tran vdout0_9ck1920 FIND v(dout0_9) AT=965.025n

.meas tran vdout0_10ck1920 FIND v(dout0_10) AT=965.025n

.meas tran vdout0_11ck1920 FIND v(dout0_11) AT=965.025n

.meas tran vdout0_12ck1920 FIND v(dout0_12) AT=965.025n

.meas tran vdout0_13ck1920 FIND v(dout0_13) AT=965.025n

.meas tran vdout0_14ck1920 FIND v(dout0_14) AT=965.025n

.meas tran vdout0_15ck1920 FIND v(dout0_15) AT=965.025n

.meas tran vdout0_16ck1920 FIND v(dout0_16) AT=965.025n

.meas tran vdout0_17ck1920 FIND v(dout0_17) AT=965.025n

.meas tran vdout0_18ck1920 FIND v(dout0_18) AT=965.025n

.meas tran vdout0_19ck1920 FIND v(dout0_19) AT=965.025n

.meas tran vdout0_20ck1920 FIND v(dout0_20) AT=965.025n

.meas tran vdout0_21ck1920 FIND v(dout0_21) AT=965.025n

.meas tran vdout0_22ck1920 FIND v(dout0_22) AT=965.025n

.meas tran vdout0_23ck1920 FIND v(dout0_23) AT=965.025n

.meas tran vdout0_24ck1920 FIND v(dout0_24) AT=965.025n

.meas tran vdout0_25ck1920 FIND v(dout0_25) AT=965.025n

.meas tran vdout0_26ck1920 FIND v(dout0_26) AT=965.025n

.meas tran vdout0_27ck1920 FIND v(dout0_27) AT=965.025n

.meas tran vdout0_28ck1920 FIND v(dout0_28) AT=965.025n

.meas tran vdout0_29ck1920 FIND v(dout0_29) AT=965.025n

.meas tran vdout0_30ck1920 FIND v(dout0_30) AT=965.025n

.meas tran vdout0_31ck1920 FIND v(dout0_31) AT=965.025n

.meas tran vdout0_0ck1930 FIND v(dout0_0) AT=970.025n

.meas tran vdout0_1ck1930 FIND v(dout0_1) AT=970.025n

.meas tran vdout0_2ck1930 FIND v(dout0_2) AT=970.025n

.meas tran vdout0_3ck1930 FIND v(dout0_3) AT=970.025n

.meas tran vdout0_4ck1930 FIND v(dout0_4) AT=970.025n

.meas tran vdout0_5ck1930 FIND v(dout0_5) AT=970.025n

.meas tran vdout0_6ck1930 FIND v(dout0_6) AT=970.025n

.meas tran vdout0_7ck1930 FIND v(dout0_7) AT=970.025n

.meas tran vdout0_8ck1930 FIND v(dout0_8) AT=970.025n

.meas tran vdout0_9ck1930 FIND v(dout0_9) AT=970.025n

.meas tran vdout0_10ck1930 FIND v(dout0_10) AT=970.025n

.meas tran vdout0_11ck1930 FIND v(dout0_11) AT=970.025n

.meas tran vdout0_12ck1930 FIND v(dout0_12) AT=970.025n

.meas tran vdout0_13ck1930 FIND v(dout0_13) AT=970.025n

.meas tran vdout0_14ck1930 FIND v(dout0_14) AT=970.025n

.meas tran vdout0_15ck1930 FIND v(dout0_15) AT=970.025n

.meas tran vdout0_16ck1930 FIND v(dout0_16) AT=970.025n

.meas tran vdout0_17ck1930 FIND v(dout0_17) AT=970.025n

.meas tran vdout0_18ck1930 FIND v(dout0_18) AT=970.025n

.meas tran vdout0_19ck1930 FIND v(dout0_19) AT=970.025n

.meas tran vdout0_20ck1930 FIND v(dout0_20) AT=970.025n

.meas tran vdout0_21ck1930 FIND v(dout0_21) AT=970.025n

.meas tran vdout0_22ck1930 FIND v(dout0_22) AT=970.025n

.meas tran vdout0_23ck1930 FIND v(dout0_23) AT=970.025n

.meas tran vdout0_24ck1930 FIND v(dout0_24) AT=970.025n

.meas tran vdout0_25ck1930 FIND v(dout0_25) AT=970.025n

.meas tran vdout0_26ck1930 FIND v(dout0_26) AT=970.025n

.meas tran vdout0_27ck1930 FIND v(dout0_27) AT=970.025n

.meas tran vdout0_28ck1930 FIND v(dout0_28) AT=970.025n

.meas tran vdout0_29ck1930 FIND v(dout0_29) AT=970.025n

.meas tran vdout0_30ck1930 FIND v(dout0_30) AT=970.025n

.meas tran vdout0_31ck1930 FIND v(dout0_31) AT=970.025n

.meas tran vdout0_0ck1970 FIND v(dout0_0) AT=990.025n

.meas tran vdout0_1ck1970 FIND v(dout0_1) AT=990.025n

.meas tran vdout0_2ck1970 FIND v(dout0_2) AT=990.025n

.meas tran vdout0_3ck1970 FIND v(dout0_3) AT=990.025n

.meas tran vdout0_4ck1970 FIND v(dout0_4) AT=990.025n

.meas tran vdout0_5ck1970 FIND v(dout0_5) AT=990.025n

.meas tran vdout0_6ck1970 FIND v(dout0_6) AT=990.025n

.meas tran vdout0_7ck1970 FIND v(dout0_7) AT=990.025n

.meas tran vdout0_8ck1970 FIND v(dout0_8) AT=990.025n

.meas tran vdout0_9ck1970 FIND v(dout0_9) AT=990.025n

.meas tran vdout0_10ck1970 FIND v(dout0_10) AT=990.025n

.meas tran vdout0_11ck1970 FIND v(dout0_11) AT=990.025n

.meas tran vdout0_12ck1970 FIND v(dout0_12) AT=990.025n

.meas tran vdout0_13ck1970 FIND v(dout0_13) AT=990.025n

.meas tran vdout0_14ck1970 FIND v(dout0_14) AT=990.025n

.meas tran vdout0_15ck1970 FIND v(dout0_15) AT=990.025n

.meas tran vdout0_16ck1970 FIND v(dout0_16) AT=990.025n

.meas tran vdout0_17ck1970 FIND v(dout0_17) AT=990.025n

.meas tran vdout0_18ck1970 FIND v(dout0_18) AT=990.025n

.meas tran vdout0_19ck1970 FIND v(dout0_19) AT=990.025n

.meas tran vdout0_20ck1970 FIND v(dout0_20) AT=990.025n

.meas tran vdout0_21ck1970 FIND v(dout0_21) AT=990.025n

.meas tran vdout0_22ck1970 FIND v(dout0_22) AT=990.025n

.meas tran vdout0_23ck1970 FIND v(dout0_23) AT=990.025n

.meas tran vdout0_24ck1970 FIND v(dout0_24) AT=990.025n

.meas tran vdout0_25ck1970 FIND v(dout0_25) AT=990.025n

.meas tran vdout0_26ck1970 FIND v(dout0_26) AT=990.025n

.meas tran vdout0_27ck1970 FIND v(dout0_27) AT=990.025n

.meas tran vdout0_28ck1970 FIND v(dout0_28) AT=990.025n

.meas tran vdout0_29ck1970 FIND v(dout0_29) AT=990.025n

.meas tran vdout0_30ck1970 FIND v(dout0_30) AT=990.025n

.meas tran vdout0_31ck1970 FIND v(dout0_31) AT=990.025n

.meas tran vdout0_0ck1980 FIND v(dout0_0) AT=995.025n

.meas tran vdout0_1ck1980 FIND v(dout0_1) AT=995.025n

.meas tran vdout0_2ck1980 FIND v(dout0_2) AT=995.025n

.meas tran vdout0_3ck1980 FIND v(dout0_3) AT=995.025n

.meas tran vdout0_4ck1980 FIND v(dout0_4) AT=995.025n

.meas tran vdout0_5ck1980 FIND v(dout0_5) AT=995.025n

.meas tran vdout0_6ck1980 FIND v(dout0_6) AT=995.025n

.meas tran vdout0_7ck1980 FIND v(dout0_7) AT=995.025n

.meas tran vdout0_8ck1980 FIND v(dout0_8) AT=995.025n

.meas tran vdout0_9ck1980 FIND v(dout0_9) AT=995.025n

.meas tran vdout0_10ck1980 FIND v(dout0_10) AT=995.025n

.meas tran vdout0_11ck1980 FIND v(dout0_11) AT=995.025n

.meas tran vdout0_12ck1980 FIND v(dout0_12) AT=995.025n

.meas tran vdout0_13ck1980 FIND v(dout0_13) AT=995.025n

.meas tran vdout0_14ck1980 FIND v(dout0_14) AT=995.025n

.meas tran vdout0_15ck1980 FIND v(dout0_15) AT=995.025n

.meas tran vdout0_16ck1980 FIND v(dout0_16) AT=995.025n

.meas tran vdout0_17ck1980 FIND v(dout0_17) AT=995.025n

.meas tran vdout0_18ck1980 FIND v(dout0_18) AT=995.025n

.meas tran vdout0_19ck1980 FIND v(dout0_19) AT=995.025n

.meas tran vdout0_20ck1980 FIND v(dout0_20) AT=995.025n

.meas tran vdout0_21ck1980 FIND v(dout0_21) AT=995.025n

.meas tran vdout0_22ck1980 FIND v(dout0_22) AT=995.025n

.meas tran vdout0_23ck1980 FIND v(dout0_23) AT=995.025n

.meas tran vdout0_24ck1980 FIND v(dout0_24) AT=995.025n

.meas tran vdout0_25ck1980 FIND v(dout0_25) AT=995.025n

.meas tran vdout0_26ck1980 FIND v(dout0_26) AT=995.025n

.meas tran vdout0_27ck1980 FIND v(dout0_27) AT=995.025n

.meas tran vdout0_28ck1980 FIND v(dout0_28) AT=995.025n

.meas tran vdout0_29ck1980 FIND v(dout0_29) AT=995.025n

.meas tran vdout0_30ck1980 FIND v(dout0_30) AT=995.025n

.meas tran vdout0_31ck1980 FIND v(dout0_31) AT=995.025n

.meas tran vdout0_0ck1990 FIND v(dout0_0) AT=1000.025n

.meas tran vdout0_1ck1990 FIND v(dout0_1) AT=1000.025n

.meas tran vdout0_2ck1990 FIND v(dout0_2) AT=1000.025n

.meas tran vdout0_3ck1990 FIND v(dout0_3) AT=1000.025n

.meas tran vdout0_4ck1990 FIND v(dout0_4) AT=1000.025n

.meas tran vdout0_5ck1990 FIND v(dout0_5) AT=1000.025n

.meas tran vdout0_6ck1990 FIND v(dout0_6) AT=1000.025n

.meas tran vdout0_7ck1990 FIND v(dout0_7) AT=1000.025n

.meas tran vdout0_8ck1990 FIND v(dout0_8) AT=1000.025n

.meas tran vdout0_9ck1990 FIND v(dout0_9) AT=1000.025n

.meas tran vdout0_10ck1990 FIND v(dout0_10) AT=1000.025n

.meas tran vdout0_11ck1990 FIND v(dout0_11) AT=1000.025n

.meas tran vdout0_12ck1990 FIND v(dout0_12) AT=1000.025n

.meas tran vdout0_13ck1990 FIND v(dout0_13) AT=1000.025n

.meas tran vdout0_14ck1990 FIND v(dout0_14) AT=1000.025n

.meas tran vdout0_15ck1990 FIND v(dout0_15) AT=1000.025n

.meas tran vdout0_16ck1990 FIND v(dout0_16) AT=1000.025n

.meas tran vdout0_17ck1990 FIND v(dout0_17) AT=1000.025n

.meas tran vdout0_18ck1990 FIND v(dout0_18) AT=1000.025n

.meas tran vdout0_19ck1990 FIND v(dout0_19) AT=1000.025n

.meas tran vdout0_20ck1990 FIND v(dout0_20) AT=1000.025n

.meas tran vdout0_21ck1990 FIND v(dout0_21) AT=1000.025n

.meas tran vdout0_22ck1990 FIND v(dout0_22) AT=1000.025n

.meas tran vdout0_23ck1990 FIND v(dout0_23) AT=1000.025n

.meas tran vdout0_24ck1990 FIND v(dout0_24) AT=1000.025n

.meas tran vdout0_25ck1990 FIND v(dout0_25) AT=1000.025n

.meas tran vdout0_26ck1990 FIND v(dout0_26) AT=1000.025n

.meas tran vdout0_27ck1990 FIND v(dout0_27) AT=1000.025n

.meas tran vdout0_28ck1990 FIND v(dout0_28) AT=1000.025n

.meas tran vdout0_29ck1990 FIND v(dout0_29) AT=1000.025n

.meas tran vdout0_30ck1990 FIND v(dout0_30) AT=1000.025n

.meas tran vdout0_31ck1990 FIND v(dout0_31) AT=1000.025n

.meas tran vdout0_0ck2000 FIND v(dout0_0) AT=1005.025n

.meas tran vdout0_1ck2000 FIND v(dout0_1) AT=1005.025n

.meas tran vdout0_2ck2000 FIND v(dout0_2) AT=1005.025n

.meas tran vdout0_3ck2000 FIND v(dout0_3) AT=1005.025n

.meas tran vdout0_4ck2000 FIND v(dout0_4) AT=1005.025n

.meas tran vdout0_5ck2000 FIND v(dout0_5) AT=1005.025n

.meas tran vdout0_6ck2000 FIND v(dout0_6) AT=1005.025n

.meas tran vdout0_7ck2000 FIND v(dout0_7) AT=1005.025n

.meas tran vdout0_8ck2000 FIND v(dout0_8) AT=1005.025n

.meas tran vdout0_9ck2000 FIND v(dout0_9) AT=1005.025n

.meas tran vdout0_10ck2000 FIND v(dout0_10) AT=1005.025n

.meas tran vdout0_11ck2000 FIND v(dout0_11) AT=1005.025n

.meas tran vdout0_12ck2000 FIND v(dout0_12) AT=1005.025n

.meas tran vdout0_13ck2000 FIND v(dout0_13) AT=1005.025n

.meas tran vdout0_14ck2000 FIND v(dout0_14) AT=1005.025n

.meas tran vdout0_15ck2000 FIND v(dout0_15) AT=1005.025n

.meas tran vdout0_16ck2000 FIND v(dout0_16) AT=1005.025n

.meas tran vdout0_17ck2000 FIND v(dout0_17) AT=1005.025n

.meas tran vdout0_18ck2000 FIND v(dout0_18) AT=1005.025n

.meas tran vdout0_19ck2000 FIND v(dout0_19) AT=1005.025n

.meas tran vdout0_20ck2000 FIND v(dout0_20) AT=1005.025n

.meas tran vdout0_21ck2000 FIND v(dout0_21) AT=1005.025n

.meas tran vdout0_22ck2000 FIND v(dout0_22) AT=1005.025n

.meas tran vdout0_23ck2000 FIND v(dout0_23) AT=1005.025n

.meas tran vdout0_24ck2000 FIND v(dout0_24) AT=1005.025n

.meas tran vdout0_25ck2000 FIND v(dout0_25) AT=1005.025n

.meas tran vdout0_26ck2000 FIND v(dout0_26) AT=1005.025n

.meas tran vdout0_27ck2000 FIND v(dout0_27) AT=1005.025n

.meas tran vdout0_28ck2000 FIND v(dout0_28) AT=1005.025n

.meas tran vdout0_29ck2000 FIND v(dout0_29) AT=1005.025n

.meas tran vdout0_30ck2000 FIND v(dout0_30) AT=1005.025n

.meas tran vdout0_31ck2000 FIND v(dout0_31) AT=1005.025n

.meas tran vdout0_0ck2020 FIND v(dout0_0) AT=1015.025n

.meas tran vdout0_1ck2020 FIND v(dout0_1) AT=1015.025n

.meas tran vdout0_2ck2020 FIND v(dout0_2) AT=1015.025n

.meas tran vdout0_3ck2020 FIND v(dout0_3) AT=1015.025n

.meas tran vdout0_4ck2020 FIND v(dout0_4) AT=1015.025n

.meas tran vdout0_5ck2020 FIND v(dout0_5) AT=1015.025n

.meas tran vdout0_6ck2020 FIND v(dout0_6) AT=1015.025n

.meas tran vdout0_7ck2020 FIND v(dout0_7) AT=1015.025n

.meas tran vdout0_8ck2020 FIND v(dout0_8) AT=1015.025n

.meas tran vdout0_9ck2020 FIND v(dout0_9) AT=1015.025n

.meas tran vdout0_10ck2020 FIND v(dout0_10) AT=1015.025n

.meas tran vdout0_11ck2020 FIND v(dout0_11) AT=1015.025n

.meas tran vdout0_12ck2020 FIND v(dout0_12) AT=1015.025n

.meas tran vdout0_13ck2020 FIND v(dout0_13) AT=1015.025n

.meas tran vdout0_14ck2020 FIND v(dout0_14) AT=1015.025n

.meas tran vdout0_15ck2020 FIND v(dout0_15) AT=1015.025n

.meas tran vdout0_16ck2020 FIND v(dout0_16) AT=1015.025n

.meas tran vdout0_17ck2020 FIND v(dout0_17) AT=1015.025n

.meas tran vdout0_18ck2020 FIND v(dout0_18) AT=1015.025n

.meas tran vdout0_19ck2020 FIND v(dout0_19) AT=1015.025n

.meas tran vdout0_20ck2020 FIND v(dout0_20) AT=1015.025n

.meas tran vdout0_21ck2020 FIND v(dout0_21) AT=1015.025n

.meas tran vdout0_22ck2020 FIND v(dout0_22) AT=1015.025n

.meas tran vdout0_23ck2020 FIND v(dout0_23) AT=1015.025n

.meas tran vdout0_24ck2020 FIND v(dout0_24) AT=1015.025n

.meas tran vdout0_25ck2020 FIND v(dout0_25) AT=1015.025n

.meas tran vdout0_26ck2020 FIND v(dout0_26) AT=1015.025n

.meas tran vdout0_27ck2020 FIND v(dout0_27) AT=1015.025n

.meas tran vdout0_28ck2020 FIND v(dout0_28) AT=1015.025n

.meas tran vdout0_29ck2020 FIND v(dout0_29) AT=1015.025n

.meas tran vdout0_30ck2020 FIND v(dout0_30) AT=1015.025n

.meas tran vdout0_31ck2020 FIND v(dout0_31) AT=1015.025n
